* NGSPICE file created from addsub32.ext - technology: sky130A

* Black-box entry subcircuit for sky130_fd_sc_hd__tapvpwrvgnd_1 abstract view
.subckt sky130_fd_sc_hd__tapvpwrvgnd_1 VGND VPWR
.ends

* Black-box entry subcircuit for sky130_fd_sc_hd__fill_1 abstract view
.subckt sky130_fd_sc_hd__fill_1 VGND VNB VPB VPWR
.ends

* Black-box entry subcircuit for sky130_fd_sc_hd__decap_3 abstract view
.subckt sky130_fd_sc_hd__decap_3 VGND VNB VPB VPWR
.ends

* Black-box entry subcircuit for sky130_fd_sc_hd__a31oi_2 abstract view
.subckt sky130_fd_sc_hd__a31oi_2 A1 A2 A3 B1 VGND VNB VPB VPWR Y
.ends

* Black-box entry subcircuit for sky130_fd_sc_hd__nand2_2 abstract view
.subckt sky130_fd_sc_hd__nand2_2 A B VGND VNB VPB VPWR Y
.ends

* Black-box entry subcircuit for sky130_fd_sc_hd__nor2_4 abstract view
.subckt sky130_fd_sc_hd__nor2_4 A B VGND VNB VPB VPWR Y
.ends

* Black-box entry subcircuit for sky130_fd_sc_hd__fill_2 abstract view
.subckt sky130_fd_sc_hd__fill_2 VGND VNB VPB VPWR
.ends

* Black-box entry subcircuit for sky130_fd_sc_hd__buf_8 abstract view
.subckt sky130_fd_sc_hd__buf_8 A VGND VNB VPB VPWR X
.ends

* Black-box entry subcircuit for sky130_fd_sc_hd__nand3_2 abstract view
.subckt sky130_fd_sc_hd__nand3_2 A B C VGND VNB VPB VPWR Y
.ends

* Black-box entry subcircuit for sky130_fd_sc_hd__a22oi_4 abstract view
.subckt sky130_fd_sc_hd__a22oi_4 A1 A2 B1 B2 VGND VNB VPB VPWR Y
.ends

* Black-box entry subcircuit for sky130_fd_sc_hd__o21ai_2 abstract view
.subckt sky130_fd_sc_hd__o21ai_2 A1 A2 B1 VGND VNB VPB VPWR Y
.ends

* Black-box entry subcircuit for sky130_fd_sc_hd__buf_6 abstract view
.subckt sky130_fd_sc_hd__buf_6 A VGND VNB VPB VPWR X
.ends

* Black-box entry subcircuit for sky130_fd_sc_hd__buf_2 abstract view
.subckt sky130_fd_sc_hd__buf_2 A VGND VNB VPB VPWR X
.ends

* Black-box entry subcircuit for sky130_fd_sc_hd__clkbuf_4 abstract view
.subckt sky130_fd_sc_hd__clkbuf_4 A VGND VNB VPB VPWR X
.ends

* Black-box entry subcircuit for sky130_fd_sc_hd__o31ai_4 abstract view
.subckt sky130_fd_sc_hd__o31ai_4 A1 A2 A3 B1 VGND VNB VPB VPWR Y
.ends

* Black-box entry subcircuit for sky130_fd_sc_hd__o21a_4 abstract view
.subckt sky130_fd_sc_hd__o21a_4 A1 A2 B1 VGND VNB VPB VPWR X
.ends

* Black-box entry subcircuit for sky130_fd_sc_hd__nor4_2 abstract view
.subckt sky130_fd_sc_hd__nor4_2 A B C D VGND VNB VPB VPWR Y
.ends

* Black-box entry subcircuit for sky130_fd_sc_hd__o21bai_4 abstract view
.subckt sky130_fd_sc_hd__o21bai_4 A1 A2 B1_N VGND VNB VPB VPWR Y
.ends

* Black-box entry subcircuit for sky130_fd_sc_hd__o21a_2 abstract view
.subckt sky130_fd_sc_hd__o21a_2 A1 A2 B1 VGND VNB VPB VPWR X
.ends

* Black-box entry subcircuit for sky130_fd_sc_hd__clkbuf_2 abstract view
.subckt sky130_fd_sc_hd__clkbuf_2 A VGND VNB VPB VPWR X
.ends

* Black-box entry subcircuit for sky130_fd_sc_hd__buf_4 abstract view
.subckt sky130_fd_sc_hd__buf_4 A VGND VNB VPB VPWR X
.ends

* Black-box entry subcircuit for sky130_fd_sc_hd__a32oi_2 abstract view
.subckt sky130_fd_sc_hd__a32oi_2 A1 A2 A3 B1 B2 VGND VNB VPB VPWR Y
.ends

* Black-box entry subcircuit for sky130_fd_sc_hd__nand2b_4 abstract view
.subckt sky130_fd_sc_hd__nand2b_4 A_N B VGND VNB VPB VPWR Y
.ends

* Black-box entry subcircuit for sky130_fd_sc_hd__nand3b_4 abstract view
.subckt sky130_fd_sc_hd__nand3b_4 A_N B C VGND VNB VPB VPWR Y
.ends

* Black-box entry subcircuit for sky130_fd_sc_hd__xnor2_2 abstract view
.subckt sky130_fd_sc_hd__xnor2_2 A B VGND VNB VPB VPWR Y
.ends

* Black-box entry subcircuit for sky130_fd_sc_hd__nand3b_2 abstract view
.subckt sky130_fd_sc_hd__nand3b_2 A_N B C VGND VNB VPB VPWR Y
.ends

* Black-box entry subcircuit for sky130_fd_sc_hd__and2_4 abstract view
.subckt sky130_fd_sc_hd__and2_4 A B VGND VNB VPB VPWR X
.ends

* Black-box entry subcircuit for sky130_fd_sc_hd__a21oi_2 abstract view
.subckt sky130_fd_sc_hd__a21oi_2 A1 A2 B1 VGND VNB VPB VPWR Y
.ends

* Black-box entry subcircuit for sky130_fd_sc_hd__dlymetal6s2s_1 abstract view
.subckt sky130_fd_sc_hd__dlymetal6s2s_1 A VGND VNB VPB VPWR X
.ends

* Black-box entry subcircuit for sky130_fd_sc_hd__or2_2 abstract view
.subckt sky130_fd_sc_hd__or2_2 A B VGND VNB VPB VPWR X
.ends

* Black-box entry subcircuit for sky130_fd_sc_hd__o2bb2ai_4 abstract view
.subckt sky130_fd_sc_hd__o2bb2ai_4 A1_N A2_N B1 B2 VGND VNB VPB VPWR Y
.ends

* Black-box entry subcircuit for sky130_fd_sc_hd__and2_2 abstract view
.subckt sky130_fd_sc_hd__and2_2 A B VGND VNB VPB VPWR X
.ends

* Black-box entry subcircuit for sky130_fd_sc_hd__nand2b_2 abstract view
.subckt sky130_fd_sc_hd__nand2b_2 A_N B VGND VNB VPB VPWR Y
.ends

* Black-box entry subcircuit for sky130_fd_sc_hd__a31oi_4 abstract view
.subckt sky130_fd_sc_hd__a31oi_4 A1 A2 A3 B1 VGND VNB VPB VPWR Y
.ends

* Black-box entry subcircuit for sky130_fd_sc_hd__and3b_2 abstract view
.subckt sky130_fd_sc_hd__and3b_2 A_N B C VGND VNB VPB VPWR X
.ends

* Black-box entry subcircuit for sky130_fd_sc_hd__nand2_4 abstract view
.subckt sky130_fd_sc_hd__nand2_4 A B VGND VNB VPB VPWR Y
.ends

* Black-box entry subcircuit for sky130_fd_sc_hd__o41a_4 abstract view
.subckt sky130_fd_sc_hd__o41a_4 A1 A2 A3 A4 B1 VGND VNB VPB VPWR X
.ends

* Black-box entry subcircuit for sky130_fd_sc_hd__xor2_2 abstract view
.subckt sky130_fd_sc_hd__xor2_2 A B VGND VNB VPB VPWR X
.ends

* Black-box entry subcircuit for sky130_fd_sc_hd__o2bb2a_4 abstract view
.subckt sky130_fd_sc_hd__o2bb2a_4 A1_N A2_N B1 B2 VGND VNB VPB VPWR X
.ends

* Black-box entry subcircuit for sky130_fd_sc_hd__o211ai_2 abstract view
.subckt sky130_fd_sc_hd__o211ai_2 A1 A2 B1 C1 VGND VNB VPB VPWR Y
.ends

* Black-box entry subcircuit for sky130_fd_sc_hd__o2bb2a_2 abstract view
.subckt sky130_fd_sc_hd__o2bb2a_2 A1_N A2_N B1 B2 VGND VNB VPB VPWR X
.ends

* Black-box entry subcircuit for sky130_fd_sc_hd__inv_2 abstract view
.subckt sky130_fd_sc_hd__inv_2 A VGND VNB VPB VPWR Y
.ends

* Black-box entry subcircuit for sky130_fd_sc_hd__o22ai_2 abstract view
.subckt sky130_fd_sc_hd__o22ai_2 A1 A2 B1 B2 VGND VNB VPB VPWR Y
.ends

* Black-box entry subcircuit for sky130_fd_sc_hd__o31ai_2 abstract view
.subckt sky130_fd_sc_hd__o31ai_2 A1 A2 A3 B1 VGND VNB VPB VPWR Y
.ends

* Black-box entry subcircuit for sky130_fd_sc_hd__nand4_4 abstract view
.subckt sky130_fd_sc_hd__nand4_4 A B C D VGND VNB VPB VPWR Y
.ends

* Black-box entry subcircuit for sky130_fd_sc_hd__nor2b_4 abstract view
.subckt sky130_fd_sc_hd__nor2b_4 A B_N VGND VNB VPB VPWR Y
.ends

* Black-box entry subcircuit for sky130_fd_sc_hd__nand3_4 abstract view
.subckt sky130_fd_sc_hd__nand3_4 A B C VGND VNB VPB VPWR Y
.ends

* Black-box entry subcircuit for sky130_fd_sc_hd__nand4b_4 abstract view
.subckt sky130_fd_sc_hd__nand4b_4 A_N B C D VGND VNB VPB VPWR Y
.ends

* Black-box entry subcircuit for sky130_fd_sc_hd__o2111a_2 abstract view
.subckt sky130_fd_sc_hd__o2111a_2 A1 A2 B1 C1 D1 VGND VNB VPB VPWR X
.ends

* Black-box entry subcircuit for sky130_fd_sc_hd__nor3_2 abstract view
.subckt sky130_fd_sc_hd__nor3_2 A B C VGND VNB VPB VPWR Y
.ends

* Black-box entry subcircuit for sky130_fd_sc_hd__o211a_4 abstract view
.subckt sky130_fd_sc_hd__o211a_4 A1 A2 B1 C1 VGND VNB VPB VPWR X
.ends

* Black-box entry subcircuit for sky130_fd_sc_hd__or2_4 abstract view
.subckt sky130_fd_sc_hd__or2_4 A B VGND VNB VPB VPWR X
.ends

* Black-box entry subcircuit for sky130_fd_sc_hd__xnor2_4 abstract view
.subckt sky130_fd_sc_hd__xnor2_4 A B VGND VNB VPB VPWR Y
.ends

* Black-box entry subcircuit for sky130_fd_sc_hd__a21oi_4 abstract view
.subckt sky130_fd_sc_hd__a21oi_4 A1 A2 B1 VGND VNB VPB VPWR Y
.ends

* Black-box entry subcircuit for sky130_fd_sc_hd__o21ai_4 abstract view
.subckt sky130_fd_sc_hd__o21ai_4 A1 A2 B1 VGND VNB VPB VPWR Y
.ends

* Black-box entry subcircuit for sky130_fd_sc_hd__nor2_2 abstract view
.subckt sky130_fd_sc_hd__nor2_2 A B VGND VNB VPB VPWR Y
.ends

* Black-box entry subcircuit for sky130_fd_sc_hd__a211oi_4 abstract view
.subckt sky130_fd_sc_hd__a211oi_4 A1 A2 B1 C1 VGND VNB VPB VPWR Y
.ends

* Black-box entry subcircuit for sky130_fd_sc_hd__a22oi_2 abstract view
.subckt sky130_fd_sc_hd__a22oi_2 A1 A2 B1 B2 VGND VNB VPB VPWR Y
.ends

* Black-box entry subcircuit for sky130_fd_sc_hd__o21bai_2 abstract view
.subckt sky130_fd_sc_hd__o21bai_2 A1 A2 B1_N VGND VNB VPB VPWR Y
.ends

* Black-box entry subcircuit for sky130_fd_sc_hd__or3b_4 abstract view
.subckt sky130_fd_sc_hd__or3b_4 A B C_N VGND VNB VPB VPWR X
.ends

* Black-box entry subcircuit for sky130_fd_sc_hd__a2bb2oi_2 abstract view
.subckt sky130_fd_sc_hd__a2bb2oi_2 A1_N A2_N B1 B2 VGND VNB VPB VPWR Y
.ends

* Black-box entry subcircuit for sky130_fd_sc_hd__and3_2 abstract view
.subckt sky130_fd_sc_hd__and3_2 A B C VGND VNB VPB VPWR X
.ends

* Black-box entry subcircuit for sky130_fd_sc_hd__a21o_2 abstract view
.subckt sky130_fd_sc_hd__a21o_2 A1 A2 B1 VGND VNB VPB VPWR X
.ends

* Black-box entry subcircuit for sky130_fd_sc_hd__clkdlybuf4s25_1 abstract view
.subckt sky130_fd_sc_hd__clkdlybuf4s25_1 A VGND VNB VPB VPWR X
.ends

* Black-box entry subcircuit for sky130_fd_sc_hd__nand4_2 abstract view
.subckt sky130_fd_sc_hd__nand4_2 A B C D VGND VNB VPB VPWR Y
.ends

* Black-box entry subcircuit for sky130_fd_sc_hd__or4_4 abstract view
.subckt sky130_fd_sc_hd__or4_4 A B C D VGND VNB VPB VPWR X
.ends

* Black-box entry subcircuit for sky130_fd_sc_hd__a21boi_2 abstract view
.subckt sky130_fd_sc_hd__a21boi_2 A1 A2 B1_N VGND VNB VPB VPWR Y
.ends

* Black-box entry subcircuit for sky130_fd_sc_hd__o31a_2 abstract view
.subckt sky130_fd_sc_hd__o31a_2 A1 A2 A3 B1 VGND VNB VPB VPWR X
.ends

* Black-box entry subcircuit for sky130_fd_sc_hd__dlymetal6s4s_1 abstract view
.subckt sky130_fd_sc_hd__dlymetal6s4s_1 A VGND VNB VPB VPWR X
.ends

* Black-box entry subcircuit for sky130_fd_sc_hd__o211a_2 abstract view
.subckt sky130_fd_sc_hd__o211a_2 A1 A2 B1 C1 VGND VNB VPB VPWR X
.ends

* Black-box entry subcircuit for sky130_fd_sc_hd__o2111ai_2 abstract view
.subckt sky130_fd_sc_hd__o2111ai_2 A1 A2 B1 C1 D1 VGND VNB VPB VPWR Y
.ends

* Black-box entry subcircuit for sky130_fd_sc_hd__a21boi_4 abstract view
.subckt sky130_fd_sc_hd__a21boi_4 A1 A2 B1_N VGND VNB VPB VPWR Y
.ends

* Black-box entry subcircuit for sky130_fd_sc_hd__a2bb2o_4 abstract view
.subckt sky130_fd_sc_hd__a2bb2o_4 A1_N A2_N B1 B2 VGND VNB VPB VPWR X
.ends

* Black-box entry subcircuit for sky130_fd_sc_hd__o32a_4 abstract view
.subckt sky130_fd_sc_hd__o32a_4 A1 A2 A3 B1 B2 VGND VNB VPB VPWR X
.ends

* Black-box entry subcircuit for sky130_fd_sc_hd__o2111ai_4 abstract view
.subckt sky130_fd_sc_hd__o2111ai_4 A1 A2 B1 C1 D1 VGND VNB VPB VPWR Y
.ends

* Black-box entry subcircuit for sky130_fd_sc_hd__mux2_1 abstract view
.subckt sky130_fd_sc_hd__mux2_1 A0 A1 S VGND VNB VPB VPWR X
.ends

* Black-box entry subcircuit for sky130_fd_sc_hd__xor2_4 abstract view
.subckt sky130_fd_sc_hd__xor2_4 A B VGND VNB VPB VPWR X
.ends

* Black-box entry subcircuit for sky130_fd_sc_hd__a41oi_4 abstract view
.subckt sky130_fd_sc_hd__a41oi_4 A1 A2 A3 A4 B1 VGND VNB VPB VPWR Y
.ends

* Black-box entry subcircuit for sky130_fd_sc_hd__o22a_2 abstract view
.subckt sky130_fd_sc_hd__o22a_2 A1 A2 B1 B2 VGND VNB VPB VPWR X
.ends

* Black-box entry subcircuit for sky130_fd_sc_hd__a2bb2o_2 abstract view
.subckt sky130_fd_sc_hd__a2bb2o_2 A1_N A2_N B1 B2 VGND VNB VPB VPWR X
.ends

* Black-box entry subcircuit for sky130_fd_sc_hd__nor2b_2 abstract view
.subckt sky130_fd_sc_hd__nor2b_2 A B_N VGND VNB VPB VPWR Y
.ends

* Black-box entry subcircuit for sky130_fd_sc_hd__nor3_4 abstract view
.subckt sky130_fd_sc_hd__nor3_4 A B C VGND VNB VPB VPWR Y
.ends

* Black-box entry subcircuit for sky130_fd_sc_hd__o22ai_4 abstract view
.subckt sky130_fd_sc_hd__o22ai_4 A1 A2 B1 B2 VGND VNB VPB VPWR Y
.ends

* Black-box entry subcircuit for sky130_fd_sc_hd__o311ai_4 abstract view
.subckt sky130_fd_sc_hd__o311ai_4 A1 A2 A3 B1 C1 VGND VNB VPB VPWR Y
.ends

* Black-box entry subcircuit for sky130_fd_sc_hd__or3_2 abstract view
.subckt sky130_fd_sc_hd__or3_2 A B C VGND VNB VPB VPWR X
.ends

* Black-box entry subcircuit for sky130_fd_sc_hd__a31o_2 abstract view
.subckt sky130_fd_sc_hd__a31o_2 A1 A2 A3 B1 VGND VNB VPB VPWR X
.ends

* Black-box entry subcircuit for sky130_fd_sc_hd__nand2_8 abstract view
.subckt sky130_fd_sc_hd__nand2_8 A B VGND VNB VPB VPWR Y
.ends

.subckt addsub32 A[0] A[10] A[11] A[12] A[13] A[14] A[15] A[16] A[17] A[18] A[19]
+ A[1] A[20] A[21] A[22] A[23] A[24] A[25] A[26] A[27] A[28] A[29] A[2] A[30] A[31]
+ A[3] A[4] A[5] A[6] A[7] A[8] A[9] B[0] B[10] B[11] B[12] B[13] B[14] B[15] B[16]
+ B[17] B[18] B[19] B[1] B[20] B[21] B[22] B[23] B[24] B[25] B[26] B[27] B[28] B[29]
+ B[2] B[30] B[31] B[3] B[4] B[5] B[6] B[7] B[8] B[9] S[0] S[10] S[11] S[12] S[13]
+ S[14] S[15] S[16] S[17] S[18] S[19] S[1] S[20] S[21] S[22] S[23] S[24] S[25] S[26]
+ S[27] S[28] S[29] S[2] S[30] S[31] S[3] S[4] S[5] S[6] S[7] S[8] S[9] VGND VPWR
+ carryOut sub
XTAP_TAPCELL_ROW_32_183 VGND VPWR sky130_fd_sc_hd__tapvpwrvgnd_1
XFILLER_22_177 VGND VGND VPWR VPWR sky130_fd_sc_hd__fill_1
XFILLER_22_122 VGND VGND VPWR VPWR sky130_fd_sc_hd__decap_3
XTAP_TAPCELL_ROW_9_104 VGND VPWR sky130_fd_sc_hd__tapvpwrvgnd_1
X_501_ _486_/C _487_/Y _496_/A _493_/Y VGND VGND VPWR VPWR _501_/Y sky130_fd_sc_hd__a31oi_2
X_432_ _452_/A _452_/B VGND VGND VPWR VPWR _433_/B sky130_fd_sc_hd__nand2_2
XFILLER_26_85 VGND VGND VPWR VPWR sky130_fd_sc_hd__decap_3
XFILLER_26_41 VGND VGND VPWR VPWR sky130_fd_sc_hd__decap_3
XFILLER_13_122 VGND VGND VPWR VPWR sky130_fd_sc_hd__decap_3
XFILLER_13_111 VGND VGND VPWR VPWR sky130_fd_sc_hd__fill_1
X_363_ _363_/A _363_/B VGND VGND VPWR VPWR _363_/Y sky130_fd_sc_hd__nor2_4
XFILLER_13_144 VGND VGND VPWR VPWR sky130_fd_sc_hd__decap_3
XFILLER_3_12 VGND VGND VPWR VPWR sky130_fd_sc_hd__fill_2
Xfanout105 input65/X VGND VGND VPWR VPWR fanout105/X sky130_fd_sc_hd__buf_8
XTAP_TAPCELL_ROW_20_142 VGND VPWR sky130_fd_sc_hd__tapvpwrvgnd_1
XFILLER_12_54 VGND VGND VPWR VPWR sky130_fd_sc_hd__decap_3
XPHY_EDGE_ROW_0_Left_34 VGND VGND VPWR VPWR sky130_fd_sc_hd__decap_3
X_415_ _415_/A _415_/B _415_/C VGND VGND VPWR VPWR _475_/C sky130_fd_sc_hd__nand3_2
X_346_ _583_/A _328_/Y _345_/Y _344_/Y VGND VGND VPWR VPWR _350_/B sky130_fd_sc_hd__a22oi_4
XTAP_TAPCELL_ROW_8_99 VGND VPWR sky130_fd_sc_hd__tapvpwrvgnd_1
XFILLER_23_53 VGND VGND VPWR VPWR sky130_fd_sc_hd__decap_3
XFILLER_17_9 VGND VGND VPWR VPWR sky130_fd_sc_hd__fill_1
XFILLER_0_57 VGND VGND VPWR VPWR sky130_fd_sc_hd__fill_1
XFILLER_0_24 VGND VGND VPWR VPWR sky130_fd_sc_hd__decap_3
X_329_ _647_/B _327_/B _583_/A VGND VGND VPWR VPWR _329_/Y sky130_fd_sc_hd__o21ai_2
XFILLER_9_66 VGND VGND VPWR VPWR sky130_fd_sc_hd__decap_3
XFILLER_9_44 VGND VGND VPWR VPWR sky130_fd_sc_hd__decap_3
XFILLER_18_97 VGND VGND VPWR VPWR sky130_fd_sc_hd__decap_3
XTAP_TAPCELL_ROW_5_89 VGND VPWR sky130_fd_sc_hd__tapvpwrvgnd_1
Xload_slew116 _369_/A VGND VGND VPWR VPWR _363_/A sky130_fd_sc_hd__buf_6
XFILLER_20_76 VGND VGND VPWR VPWR sky130_fd_sc_hd__decap_3
XFILLER_20_32 VGND VGND VPWR VPWR sky130_fd_sc_hd__decap_3
XFILLER_29_41 VGND VGND VPWR VPWR sky130_fd_sc_hd__fill_2
X_594_ _599_/B _593_/B _581_/A VGND VGND VPWR VPWR _594_/Y sky130_fd_sc_hd__o21ai_2
XFILLER_28_194 VGND VGND VPWR VPWR sky130_fd_sc_hd__fill_2
XFILLER_28_161 VGND VGND VPWR VPWR sky130_fd_sc_hd__decap_3
Xrebuffer129 _623_/B VGND VGND VPWR VPWR _568_/A sky130_fd_sc_hd__buf_2
XFILLER_25_175 VGND VGND VPWR VPWR sky130_fd_sc_hd__fill_1
XFILLER_25_131 VGND VGND VPWR VPWR sky130_fd_sc_hd__decap_3
XFILLER_31_20 VGND VGND VPWR VPWR sky130_fd_sc_hd__decap_3
XFILLER_25_186 VGND VGND VPWR VPWR sky130_fd_sc_hd__decap_3
XFILLER_15_87 VGND VGND VPWR VPWR sky130_fd_sc_hd__decap_3
Xoutput75 _412_/X VGND VGND VPWR VPWR S[18] sky130_fd_sc_hd__clkbuf_4
XTAP_TAPCELL_ROW_2_79 VGND VPWR sky130_fd_sc_hd__tapvpwrvgnd_1
Xoutput97 _565_/Y VGND VGND VPWR VPWR S[9] sky130_fd_sc_hd__buf_6
Xoutput86 _519_/Y VGND VGND VPWR VPWR S[28] sky130_fd_sc_hd__buf_6
X_577_ _577_/A1 _576_/A _571_/X _384_/B VGND VGND VPWR VPWR _578_/B sky130_fd_sc_hd__o31ai_4
X_646_ _638_/X _639_/Y _645_/Y VGND VGND VPWR VPWR _657_/A sky130_fd_sc_hd__o21a_4
XTAP_TAPCELL_ROW_18_137 VGND VPWR sky130_fd_sc_hd__tapvpwrvgnd_1
XFILLER_16_186 VGND VGND VPWR VPWR sky130_fd_sc_hd__fill_1
XFILLER_16_153 VGND VGND VPWR VPWR sky130_fd_sc_hd__fill_1
XTAP_TAPCELL_ROW_32_184 VGND VPWR sky130_fd_sc_hd__tapvpwrvgnd_1
XFILLER_22_134 VGND VGND VPWR VPWR sky130_fd_sc_hd__decap_3
XFILLER_22_101 VGND VGND VPWR VPWR sky130_fd_sc_hd__decap_3
XTAP_TAPCELL_ROW_9_105 VGND VPWR sky130_fd_sc_hd__tapvpwrvgnd_1
X_500_ _500_/A _500_/B _500_/C _500_/D VGND VGND VPWR VPWR _500_/Y sky130_fd_sc_hd__nor4_2
X_431_ _427_/X _429_/Y _430_/B VGND VGND VPWR VPWR _452_/B sky130_fd_sc_hd__o21bai_4
X_362_ _363_/A _363_/B VGND VGND VPWR VPWR _364_/C sky130_fd_sc_hd__nand2_2
XFILLER_9_116 VGND VGND VPWR VPWR sky130_fd_sc_hd__fill_1
XFILLER_26_53 VGND VGND VPWR VPWR sky130_fd_sc_hd__decap_3
XFILLER_13_156 VGND VGND VPWR VPWR sky130_fd_sc_hd__decap_3
XFILLER_13_134 VGND VGND VPWR VPWR sky130_fd_sc_hd__decap_3
XFILLER_9_149 VGND VGND VPWR VPWR sky130_fd_sc_hd__fill_2
X_629_ _629_/A1 _582_/Y _628_/Y VGND VGND VPWR VPWR _629_/X sky130_fd_sc_hd__o21a_2
Xfanout106 input65/X VGND VGND VPWR VPWR _490_/A sky130_fd_sc_hd__clkbuf_2
Xfanout117 _539_/A VGND VGND VPWR VPWR _529_/A sky130_fd_sc_hd__buf_4
XTAP_TAPCELL_ROW_20_143 VGND VPWR sky130_fd_sc_hd__tapvpwrvgnd_1
XFILLER_12_88 VGND VGND VPWR VPWR sky130_fd_sc_hd__decap_3
XFILLER_12_66 VGND VGND VPWR VPWR sky130_fd_sc_hd__decap_3
XFILLER_10_115 VGND VGND VPWR VPWR sky130_fd_sc_hd__fill_2
XFILLER_10_104 VGND VGND VPWR VPWR sky130_fd_sc_hd__fill_1
X_414_ _490_/A _414_/B VGND VGND VPWR VPWR _415_/B sky130_fd_sc_hd__nand2_2
X_345_ _583_/Y _330_/B _330_/C _336_/Y _584_/Y VGND VGND VPWR VPWR _345_/Y sky130_fd_sc_hd__a32oi_2
XTAP_TAPCELL_ROW_11_110 VGND VPWR sky130_fd_sc_hd__tapvpwrvgnd_1
XFILLER_5_185 VGND VGND VPWR VPWR sky130_fd_sc_hd__fill_1
XPHY_EDGE_ROW_12_Right_12 VGND VGND VPWR VPWR sky130_fd_sc_hd__decap_3
XPHY_EDGE_ROW_21_Right_21 VGND VGND VPWR VPWR sky130_fd_sc_hd__decap_3
XFILLER_23_32 VGND VGND VPWR VPWR sky130_fd_sc_hd__decap_3
XPHY_EDGE_ROW_30_Right_30 VGND VGND VPWR VPWR sky130_fd_sc_hd__decap_3
XFILLER_2_122 VGND VGND VPWR VPWR sky130_fd_sc_hd__decap_3
XFILLER_23_65 VGND VGND VPWR VPWR sky130_fd_sc_hd__decap_3
X_328_ _330_/B _330_/C VGND VGND VPWR VPWR _328_/Y sky130_fd_sc_hd__nand2_2
XFILLER_18_54 VGND VGND VPWR VPWR sky130_fd_sc_hd__decap_3
XFILLER_20_88 VGND VGND VPWR VPWR sky130_fd_sc_hd__decap_3
XFILLER_20_55 VGND VGND VPWR VPWR sky130_fd_sc_hd__decap_3
XFILLER_29_75 VGND VGND VPWR VPWR sky130_fd_sc_hd__decap_3
X_593_ _597_/A _593_/B VGND VGND VPWR VPWR _595_/C sky130_fd_sc_hd__nand2b_4
XFILLER_28_173 VGND VGND VPWR VPWR sky130_fd_sc_hd__decap_3
XFILLER_19_140 VGND VGND VPWR VPWR sky130_fd_sc_hd__decap_3
Xrebuffer119 _500_/D VGND VGND VPWR VPWR _497_/A2 sky130_fd_sc_hd__buf_6
XPHY_EDGE_ROW_6_Right_6 VGND VGND VPWR VPWR sky130_fd_sc_hd__decap_3
XFILLER_25_143 VGND VGND VPWR VPWR sky130_fd_sc_hd__decap_3
XFILLER_15_66 VGND VGND VPWR VPWR sky130_fd_sc_hd__decap_3
XFILLER_31_43 VGND VGND VPWR VPWR sky130_fd_sc_hd__decap_3
XFILLER_31_32 VGND VGND VPWR VPWR sky130_fd_sc_hd__fill_1
XFILLER_31_10 VGND VGND VPWR VPWR sky130_fd_sc_hd__fill_1
XFILLER_15_99 VGND VGND VPWR VPWR sky130_fd_sc_hd__decap_3
Xoutput98 _579_/Y VGND VGND VPWR VPWR carryOut sky130_fd_sc_hd__buf_6
Xoutput87 _524_/Y VGND VGND VPWR VPWR S[29] sky130_fd_sc_hd__buf_6
Xoutput76 _423_/Y VGND VGND VPWR VPWR S[19] sky130_fd_sc_hd__buf_6
X_645_ _639_/B1 _645_/B _645_/C VGND VGND VPWR VPWR _645_/Y sky130_fd_sc_hd__nand3b_4
XFILLER_16_121 VGND VGND VPWR VPWR sky130_fd_sc_hd__decap_3
X_576_ _576_/A _576_/B VGND VGND VPWR VPWR _576_/Y sky130_fd_sc_hd__xnor2_2
XFILLER_31_113 VGND VGND VPWR VPWR sky130_fd_sc_hd__fill_1
XFILLER_22_113 VGND VGND VPWR VPWR sky130_fd_sc_hd__fill_1
XTAP_TAPCELL_ROW_32_185 VGND VPWR sky130_fd_sc_hd__tapvpwrvgnd_1
XFILLER_26_32 VGND VGND VPWR VPWR sky130_fd_sc_hd__decap_3
X_430_ _429_/Y _430_/B _430_/C VGND VGND VPWR VPWR _452_/A sky130_fd_sc_hd__nand3b_2
X_361_ _363_/A _363_/B VGND VGND VPWR VPWR _361_/X sky130_fd_sc_hd__and2_4
XTAP_TAPCELL_ROW_23_152 VGND VPWR sky130_fd_sc_hd__tapvpwrvgnd_1
XFILLER_13_113 VGND VGND VPWR VPWR sky130_fd_sc_hd__decap_3
XFILLER_13_102 VGND VGND VPWR VPWR sky130_fd_sc_hd__decap_3
XFILLER_3_47 VGND VGND VPWR VPWR sky130_fd_sc_hd__fill_1
X_628_ _582_/Y _629_/A1 _628_/B1 VGND VGND VPWR VPWR _628_/Y sky130_fd_sc_hd__a21oi_2
X_559_ _559_/A _657_/C VGND VGND VPWR VPWR _559_/Y sky130_fd_sc_hd__xnor2_2
Xfanout107 input65/X VGND VGND VPWR VPWR _521_/A sky130_fd_sc_hd__dlymetal6s2s_1
Xfanout118 input65/X VGND VGND VPWR VPWR _539_/A sky130_fd_sc_hd__buf_8
XFILLER_8_194 VGND VGND VPWR VPWR sky130_fd_sc_hd__fill_2
XTAP_TAPCELL_ROW_20_144 VGND VPWR sky130_fd_sc_hd__tapvpwrvgnd_1
XFILLER_12_78 VGND VGND VPWR VPWR sky130_fd_sc_hd__decap_3
XFILLER_10_149 VGND VGND VPWR VPWR sky130_fd_sc_hd__decap_3
XFILLER_10_138 VGND VGND VPWR VPWR sky130_fd_sc_hd__fill_2
X_413_ _490_/A _414_/B VGND VGND VPWR VPWR _415_/A sky130_fd_sc_hd__or2_2
X_344_ _341_/C _342_/Y _336_/Y _584_/Y VGND VGND VPWR VPWR _344_/Y sky130_fd_sc_hd__o2bb2ai_4
XTAP_TAPCELL_ROW_11_111 VGND VPWR sky130_fd_sc_hd__tapvpwrvgnd_1
XFILLER_5_153 VGND VGND VPWR VPWR sky130_fd_sc_hd__fill_2
XFILLER_23_44 VGND VGND VPWR VPWR sky130_fd_sc_hd__decap_3
XFILLER_3_3 VGND VGND VPWR VPWR sky130_fd_sc_hd__decap_3
XFILLER_0_15 VGND VGND VPWR VPWR sky130_fd_sc_hd__decap_3
X_327_ _647_/B _327_/B VGND VGND VPWR VPWR _327_/X sky130_fd_sc_hd__and2_2
XFILLER_9_57 VGND VGND VPWR VPWR sky130_fd_sc_hd__decap_3
XFILLER_18_88 VGND VGND VPWR VPWR sky130_fd_sc_hd__decap_3
XFILLER_29_119 VGND VGND VPWR VPWR sky130_fd_sc_hd__fill_1
XFILLER_20_67 VGND VGND VPWR VPWR sky130_fd_sc_hd__decap_3
X_592_ _593_/B _597_/A VGND VGND VPWR VPWR _595_/B sky130_fd_sc_hd__nand2b_2
XFILLER_28_152 VGND VGND VPWR VPWR sky130_fd_sc_hd__decap_3
XFILLER_19_185 VGND VGND VPWR VPWR sky130_fd_sc_hd__fill_1
XFILLER_25_166 VGND VGND VPWR VPWR sky130_fd_sc_hd__fill_2
XFILLER_25_122 VGND VGND VPWR VPWR sky130_fd_sc_hd__decap_3
XFILLER_25_100 VGND VGND VPWR VPWR sky130_fd_sc_hd__decap_3
XFILLER_15_78 VGND VGND VPWR VPWR sky130_fd_sc_hd__decap_3
XFILLER_15_45 VGND VGND VPWR VPWR sky130_fd_sc_hd__decap_3
Xoutput88 _550_/X VGND VGND VPWR VPWR S[2] sky130_fd_sc_hd__buf_6
Xoutput77 _548_/Y VGND VGND VPWR VPWR S[1] sky130_fd_sc_hd__buf_6
Xoutput66 _546_/Y VGND VGND VPWR VPWR S[0] sky130_fd_sc_hd__buf_6
X_575_ _571_/X _575_/A2 _360_/A _357_/Y VGND VGND VPWR VPWR _576_/B sky130_fd_sc_hd__a31oi_4
X_644_ _639_/B1 _645_/B _645_/C VGND VGND VPWR VPWR _644_/X sky130_fd_sc_hd__and3b_2
XFILLER_16_133 VGND VGND VPWR VPWR sky130_fd_sc_hd__decap_3
XFILLER_16_100 VGND VGND VPWR VPWR sky130_fd_sc_hd__decap_3
XFILLER_31_169 VGND VGND VPWR VPWR sky130_fd_sc_hd__decap_3
XFILLER_22_125 VGND VGND VPWR VPWR sky130_fd_sc_hd__decap_3
XTAP_TAPCELL_ROW_32_186 VGND VPWR sky130_fd_sc_hd__tapvpwrvgnd_1
X_360_ _360_/A _360_/B VGND VGND VPWR VPWR _380_/D sky130_fd_sc_hd__nand2_4
XTAP_TAPCELL_ROW_23_153 VGND VPWR sky130_fd_sc_hd__tapvpwrvgnd_1
XFILLER_26_88 VGND VGND VPWR VPWR sky130_fd_sc_hd__fill_2
XFILLER_13_169 VGND VGND VPWR VPWR sky130_fd_sc_hd__decap_3
XFILLER_13_147 VGND VGND VPWR VPWR sky130_fd_sc_hd__fill_1
XFILLER_13_125 VGND VGND VPWR VPWR sky130_fd_sc_hd__decap_3
X_558_ _640_/Y _643_/Y _644_/X _558_/A4 _641_/X VGND VGND VPWR VPWR _559_/A sky130_fd_sc_hd__o41a_4
X_627_ _629_/A1 _625_/B _626_/Y VGND VGND VPWR VPWR _627_/Y sky130_fd_sc_hd__a21oi_2
XTAP_TAPCELL_ROW_14_120 VGND VPWR sky130_fd_sc_hd__tapvpwrvgnd_1
X_489_ _490_/A _490_/B VGND VGND VPWR VPWR _492_/C sky130_fd_sc_hd__nand2_2
XPHY_EDGE_ROW_19_Left_53 VGND VGND VPWR VPWR sky130_fd_sc_hd__decap_3
XFILLER_12_57 VGND VGND VPWR VPWR sky130_fd_sc_hd__decap_3
X_412_ _425_/C _412_/B VGND VGND VPWR VPWR _412_/X sky130_fd_sc_hd__xor2_2
X_343_ _324_/C _549_/A2 _336_/Y _584_/Y VGND VGND VPWR VPWR _343_/X sky130_fd_sc_hd__o2bb2a_4
XTAP_TAPCELL_ROW_11_112 VGND VPWR sky130_fd_sc_hd__tapvpwrvgnd_1
XFILLER_5_110 VGND VGND VPWR VPWR sky130_fd_sc_hd__fill_2
XFILLER_5_198 VGND VGND VPWR VPWR sky130_fd_sc_hd__decap_3
XPHY_EDGE_ROW_4_Left_38 VGND VGND VPWR VPWR sky130_fd_sc_hd__decap_3
XFILLER_2_179 VGND VGND VPWR VPWR sky130_fd_sc_hd__decap_3
XFILLER_0_27 VGND VGND VPWR VPWR sky130_fd_sc_hd__fill_1
X_326_ _647_/B _327_/B VGND VGND VPWR VPWR _330_/C sky130_fd_sc_hd__nand2b_4
XFILLER_9_69 VGND VGND VPWR VPWR sky130_fd_sc_hd__decap_3
XFILLER_9_47 VGND VGND VPWR VPWR sky130_fd_sc_hd__decap_3
XTAP_TAPCELL_ROW_0_70 VGND VPWR sky130_fd_sc_hd__tapvpwrvgnd_1
XFILLER_18_45 VGND VGND VPWR VPWR sky130_fd_sc_hd__decap_3
XFILLER_18_78 VGND VGND VPWR VPWR sky130_fd_sc_hd__decap_3
Xload_slew108 _521_/A VGND VGND VPWR VPWR _503_/A sky130_fd_sc_hd__buf_2
XFILLER_20_79 VGND VGND VPWR VPWR sky130_fd_sc_hd__decap_3
XFILLER_20_35 VGND VGND VPWR VPWR sky130_fd_sc_hd__decap_3
X_591_ _599_/B _593_/B VGND VGND VPWR VPWR _591_/X sky130_fd_sc_hd__and2_4
XFILLER_28_197 VGND VGND VPWR VPWR sky130_fd_sc_hd__decap_3
XFILLER_28_164 VGND VGND VPWR VPWR sky130_fd_sc_hd__decap_3
XPHY_EDGE_ROW_7_Left_41 VGND VGND VPWR VPWR sky130_fd_sc_hd__decap_3
XFILLER_19_131 VGND VGND VPWR VPWR sky130_fd_sc_hd__decap_3
XFILLER_25_134 VGND VGND VPWR VPWR sky130_fd_sc_hd__decap_3
XFILLER_15_57 VGND VGND VPWR VPWR sky130_fd_sc_hd__decap_3
XPHY_EDGE_ROW_33_Left_67 VGND VGND VPWR VPWR sky130_fd_sc_hd__decap_3
XFILLER_31_23 VGND VGND VPWR VPWR sky130_fd_sc_hd__decap_3
Xoutput89 _538_/Y VGND VGND VPWR VPWR S[30] sky130_fd_sc_hd__buf_6
Xoutput78 _433_/Y VGND VGND VPWR VPWR S[20] sky130_fd_sc_hd__buf_6
Xoutput67 _568_/Y VGND VGND VPWR VPWR S[10] sky130_fd_sc_hd__buf_6
XFILLER_0_200 VGND VGND VPWR VPWR sky130_fd_sc_hd__fill_2
X_574_ _574_/A _574_/B VGND VGND VPWR VPWR _574_/Y sky130_fd_sc_hd__xnor2_2
X_643_ _630_/X _634_/Y _651_/A1 VGND VGND VPWR VPWR _643_/Y sky130_fd_sc_hd__o21ai_2
XTAP_TAPCELL_ROW_26_162 VGND VPWR sky130_fd_sc_hd__tapvpwrvgnd_1
XFILLER_16_112 VGND VGND VPWR VPWR sky130_fd_sc_hd__decap_3
XFILLER_11_3 VGND VGND VPWR VPWR sky130_fd_sc_hd__decap_3
XFILLER_22_137 VGND VGND VPWR VPWR sky130_fd_sc_hd__decap_3
XFILLER_26_56 VGND VGND VPWR VPWR sky130_fd_sc_hd__decap_3
XTAP_TAPCELL_ROW_23_154 VGND VPWR sky130_fd_sc_hd__tapvpwrvgnd_1
XFILLER_13_159 VGND VGND VPWR VPWR sky130_fd_sc_hd__fill_1
X_488_ _486_/Y _497_/A2 _486_/C _487_/Y VGND VGND VPWR VPWR _498_/A sky130_fd_sc_hd__o211ai_2
X_557_ _557_/A _557_/B VGND VGND VPWR VPWR _557_/X sky130_fd_sc_hd__xor2_2
X_626_ _631_/B _625_/B _628_/B1 VGND VGND VPWR VPWR _626_/Y sky130_fd_sc_hd__o21ai_2
XTAP_TAPCELL_ROW_14_121 VGND VPWR sky130_fd_sc_hd__tapvpwrvgnd_1
XFILLER_8_174 VGND VGND VPWR VPWR sky130_fd_sc_hd__decap_3
Xfanout109 _631_/B VGND VGND VPWR VPWR _599_/B sky130_fd_sc_hd__buf_8
XFILLER_12_69 VGND VGND VPWR VPWR sky130_fd_sc_hd__decap_3
X_411_ _409_/C _410_/Y _419_/B _385_/Y VGND VGND VPWR VPWR _412_/B sky130_fd_sc_hd__o2bb2a_2
X_342_ _317_/B _316_/X _319_/X _321_/Y VGND VGND VPWR VPWR _342_/Y sky130_fd_sc_hd__o2bb2ai_4
XFILLER_5_144 VGND VGND VPWR VPWR sky130_fd_sc_hd__decap_3
X_609_ _608_/A _610_/A VGND VGND VPWR VPWR _609_/Y sky130_fd_sc_hd__nand2b_2
XPHY_EDGE_ROW_20_Left_54 VGND VGND VPWR VPWR sky130_fd_sc_hd__decap_3
XFILLER_4_81 VGND VGND VPWR VPWR sky130_fd_sc_hd__decap_3
XFILLER_23_68 VGND VGND VPWR VPWR sky130_fd_sc_hd__decap_3
XFILLER_23_57 VGND VGND VPWR VPWR sky130_fd_sc_hd__fill_1
XFILLER_23_35 VGND VGND VPWR VPWR sky130_fd_sc_hd__decap_3
X_325_ _327_/B _647_/B VGND VGND VPWR VPWR _330_/B sky130_fd_sc_hd__nand2b_2
XFILLER_13_90 VGND VGND VPWR VPWR sky130_fd_sc_hd__decap_3
XTAP_TAPCELL_ROW_0_71 VGND VPWR sky130_fd_sc_hd__tapvpwrvgnd_1
XFILLER_18_57 VGND VGND VPWR VPWR sky130_fd_sc_hd__fill_1
XFILLER_20_58 VGND VGND VPWR VPWR sky130_fd_sc_hd__decap_3
XFILLER_20_47 VGND VGND VPWR VPWR sky130_fd_sc_hd__fill_1
XFILLER_29_78 VGND VGND VPWR VPWR sky130_fd_sc_hd__decap_3
XFILLER_29_23 VGND VGND VPWR VPWR sky130_fd_sc_hd__decap_3
X_590_ _590_/A VGND VGND VPWR VPWR _590_/Y sky130_fd_sc_hd__inv_2
XFILLER_28_176 VGND VGND VPWR VPWR sky130_fd_sc_hd__decap_3
XFILLER_6_27 VGND VGND VPWR VPWR sky130_fd_sc_hd__fill_1
XFILLER_19_143 VGND VGND VPWR VPWR sky130_fd_sc_hd__decap_3
XTAP_TAPCELL_ROW_6_92 VGND VPWR sky130_fd_sc_hd__tapvpwrvgnd_1
XFILLER_25_146 VGND VGND VPWR VPWR sky130_fd_sc_hd__decap_3
XFILLER_25_113 VGND VGND VPWR VPWR sky130_fd_sc_hd__decap_3
XFILLER_15_69 VGND VGND VPWR VPWR sky130_fd_sc_hd__decap_3
XFILLER_15_36 VGND VGND VPWR VPWR sky130_fd_sc_hd__decap_3
XFILLER_31_57 VGND VGND VPWR VPWR sky130_fd_sc_hd__fill_2
XFILLER_31_46 VGND VGND VPWR VPWR sky130_fd_sc_hd__fill_2
X_642_ _630_/X _634_/Y _633_/Y VGND VGND VPWR VPWR _657_/B sky130_fd_sc_hd__o21a_4
Xoutput79 _441_/X VGND VGND VPWR VPWR S[21] sky130_fd_sc_hd__buf_6
Xoutput68 _570_/X VGND VGND VPWR VPWR S[11] sky130_fd_sc_hd__clkbuf_4
X_573_ _572_/A _573_/A2 _575_/A2 VGND VGND VPWR VPWR _574_/B sky130_fd_sc_hd__o21ai_2
XTAP_TAPCELL_ROW_26_163 VGND VPWR sky130_fd_sc_hd__tapvpwrvgnd_1
XPHY_EDGE_ROW_19_Right_19 VGND VGND VPWR VPWR sky130_fd_sc_hd__decap_3
XFILLER_16_124 VGND VGND VPWR VPWR sky130_fd_sc_hd__decap_3
XPHY_EDGE_ROW_28_Right_28 VGND VGND VPWR VPWR sky130_fd_sc_hd__decap_3
XFILLER_26_68 VGND VGND VPWR VPWR sky130_fd_sc_hd__fill_1
XFILLER_26_35 VGND VGND VPWR VPWR sky130_fd_sc_hd__fill_1
XFILLER_13_116 VGND VGND VPWR VPWR sky130_fd_sc_hd__decap_3
XFILLER_13_105 VGND VGND VPWR VPWR sky130_fd_sc_hd__decap_3
X_625_ _625_/A _625_/B VGND VGND VPWR VPWR _625_/Y sky130_fd_sc_hd__nand2_2
X_487_ _487_/A _487_/B VGND VGND VPWR VPWR _487_/Y sky130_fd_sc_hd__nand2_2
X_556_ _638_/X _639_/Y _644_/X _555_/B VGND VGND VPWR VPWR _557_/B sky130_fd_sc_hd__o22ai_2
XTAP_TAPCELL_ROW_14_122 VGND VPWR sky130_fd_sc_hd__tapvpwrvgnd_1
XFILLER_12_160 VGND VGND VPWR VPWR sky130_fd_sc_hd__decap_3
XTAP_TAPCELL_ROW_3_82 VGND VPWR sky130_fd_sc_hd__tapvpwrvgnd_1
XFILLER_12_48 VGND VGND VPWR VPWR sky130_fd_sc_hd__decap_3
XFILLER_12_37 VGND VGND VPWR VPWR sky130_fd_sc_hd__fill_1
X_410_ _397_/B _585_/Y _397_/A _409_/A VGND VGND VPWR VPWR _410_/Y sky130_fd_sc_hd__o31ai_2
X_341_ _341_/A _341_/B _341_/C _341_/D VGND VGND VPWR VPWR _350_/A sky130_fd_sc_hd__nand4_4
X_608_ _608_/A _610_/A VGND VGND VPWR VPWR _608_/Y sky130_fd_sc_hd__nor2b_4
XFILLER_32_200 VGND VGND VPWR VPWR sky130_fd_sc_hd__fill_2
X_539_ _539_/A _539_/B VGND VGND VPWR VPWR _541_/B sky130_fd_sc_hd__xnor2_2
XFILLER_2_104 VGND VGND VPWR VPWR sky130_fd_sc_hd__decap_3
XFILLER_23_47 VGND VGND VPWR VPWR sky130_fd_sc_hd__decap_3
XFILLER_3_6 VGND VGND VPWR VPWR sky130_fd_sc_hd__decap_3
XFILLER_0_29 VGND VGND VPWR VPWR sky130_fd_sc_hd__decap_3
XFILLER_0_18 VGND VGND VPWR VPWR sky130_fd_sc_hd__decap_3
X_324_ _324_/A _341_/D _324_/C VGND VGND VPWR VPWR _324_/Y sky130_fd_sc_hd__nand3_4
XTAP_TAPCELL_ROW_0_72 VGND VPWR sky130_fd_sc_hd__tapvpwrvgnd_1
XFILLER_1_3 VGND VGND VPWR VPWR sky130_fd_sc_hd__decap_3
XFILLER_20_26 VGND VGND VPWR VPWR sky130_fd_sc_hd__fill_2
XFILLER_29_57 VGND VGND VPWR VPWR sky130_fd_sc_hd__decap_3
XFILLER_28_122 VGND VGND VPWR VPWR sky130_fd_sc_hd__decap_3
XFILLER_28_155 VGND VGND VPWR VPWR sky130_fd_sc_hd__decap_3
XFILLER_28_133 VGND VGND VPWR VPWR sky130_fd_sc_hd__decap_3
XFILLER_10_92 VGND VGND VPWR VPWR sky130_fd_sc_hd__decap_3
XFILLER_19_122 VGND VGND VPWR VPWR sky130_fd_sc_hd__decap_3
XFILLER_19_100 VGND VGND VPWR VPWR sky130_fd_sc_hd__fill_2
XTAP_TAPCELL_ROW_6_93 VGND VPWR sky130_fd_sc_hd__tapvpwrvgnd_1
XFILLER_25_169 VGND VGND VPWR VPWR sky130_fd_sc_hd__decap_3
XFILLER_25_125 VGND VGND VPWR VPWR sky130_fd_sc_hd__decap_3
XFILLER_25_103 VGND VGND VPWR VPWR sky130_fd_sc_hd__fill_2
XFILLER_15_48 VGND VGND VPWR VPWR sky130_fd_sc_hd__fill_1
Xoutput69 _572_/Y VGND VGND VPWR VPWR S[12] sky130_fd_sc_hd__buf_6
X_572_ _572_/A _572_/B VGND VGND VPWR VPWR _572_/Y sky130_fd_sc_hd__xnor2_2
X_641_ _640_/Y _651_/A1 _630_/X _634_/Y VGND VGND VPWR VPWR _641_/X sky130_fd_sc_hd__o2bb2a_2
XFILLER_16_103 VGND VGND VPWR VPWR sky130_fd_sc_hd__decap_3
XTAP_TAPCELL_ROW_26_164 VGND VPWR sky130_fd_sc_hd__tapvpwrvgnd_1
XFILLER_16_136 VGND VGND VPWR VPWR sky130_fd_sc_hd__decap_3
XTAP_TAPCELL_ROW_17_131 VGND VPWR sky130_fd_sc_hd__tapvpwrvgnd_1
XFILLER_30_194 VGND VGND VPWR VPWR sky130_fd_sc_hd__fill_2
XFILLER_22_128 VGND VGND VPWR VPWR sky130_fd_sc_hd__decap_3
XFILLER_7_71 VGND VGND VPWR VPWR sky130_fd_sc_hd__decap_3
XFILLER_26_25 VGND VGND VPWR VPWR sky130_fd_sc_hd__decap_3
XFILLER_13_128 VGND VGND VPWR VPWR sky130_fd_sc_hd__decap_3
XFILLER_21_161 VGND VGND VPWR VPWR sky130_fd_sc_hd__decap_3
X_555_ _555_/A _555_/B VGND VGND VPWR VPWR _555_/Y sky130_fd_sc_hd__xnor2_2
X_624_ _624_/A VGND VGND VPWR VPWR _624_/Y sky130_fd_sc_hd__inv_2
X_486_ _471_/A _486_/B _486_/C _487_/B VGND VGND VPWR VPWR _486_/Y sky130_fd_sc_hd__nand4b_4
XTAP_TAPCELL_ROW_14_123 VGND VPWR sky130_fd_sc_hd__tapvpwrvgnd_1
XFILLER_16_91 VGND VGND VPWR VPWR sky130_fd_sc_hd__decap_3
XTAP_TAPCELL_ROW_3_83 VGND VPWR sky130_fd_sc_hd__tapvpwrvgnd_1
XFILLER_12_27 VGND VGND VPWR VPWR sky130_fd_sc_hd__fill_1
X_340_ _329_/Y _327_/X _339_/A _339_/B _330_/Y VGND VGND VPWR VPWR _341_/A sky130_fd_sc_hd__o2111a_2
XFILLER_5_113 VGND VGND VPWR VPWR sky130_fd_sc_hd__fill_1
X_538_ _538_/A _538_/B VGND VGND VPWR VPWR _538_/Y sky130_fd_sc_hd__nor2_4
X_607_ _594_/Y _591_/X _603_/Y _605_/Y _595_/Y VGND VGND VPWR VPWR _607_/X sky130_fd_sc_hd__o2111a_2
X_469_ _470_/A _587_/Y _470_/C VGND VGND VPWR VPWR _487_/A sky130_fd_sc_hd__nor3_2
XFILLER_23_201 VGND VGND VPWR VPWR sky130_fd_sc_hd__fill_1
XFILLER_2_138 VGND VGND VPWR VPWR sky130_fd_sc_hd__fill_2
XFILLER_2_149 VGND VGND VPWR VPWR sky130_fd_sc_hd__fill_1
X_323_ _547_/S _321_/Y _322_/Y _658_/B VGND VGND VPWR VPWR _341_/B sky130_fd_sc_hd__o211a_4
XFILLER_13_81 VGND VGND VPWR VPWR sky130_fd_sc_hd__decap_3
XTAP_TAPCELL_ROW_0_73 VGND VPWR sky130_fd_sc_hd__tapvpwrvgnd_1
XFILLER_18_48 VGND VGND VPWR VPWR sky130_fd_sc_hd__decap_3
XFILLER_20_38 VGND VGND VPWR VPWR sky130_fd_sc_hd__decap_3
XFILLER_29_69 VGND VGND VPWR VPWR sky130_fd_sc_hd__decap_3
XFILLER_28_101 VGND VGND VPWR VPWR sky130_fd_sc_hd__decap_3
XFILLER_28_167 VGND VGND VPWR VPWR sky130_fd_sc_hd__decap_3
XFILLER_10_60 VGND VGND VPWR VPWR sky130_fd_sc_hd__decap_3
XTAP_TAPCELL_ROW_29_173 VGND VPWR sky130_fd_sc_hd__tapvpwrvgnd_1
XFILLER_19_167 VGND VGND VPWR VPWR sky130_fd_sc_hd__fill_1
XFILLER_19_134 VGND VGND VPWR VPWR sky130_fd_sc_hd__decap_3
XTAP_TAPCELL_ROW_6_94 VGND VPWR sky130_fd_sc_hd__tapvpwrvgnd_1
XFILLER_25_137 VGND VGND VPWR VPWR sky130_fd_sc_hd__decap_3
XFILLER_31_26 VGND VGND VPWR VPWR sky130_fd_sc_hd__decap_3
XPHY_EDGE_ROW_1_Right_1 VGND VGND VPWR VPWR sky130_fd_sc_hd__decap_3
X_571_ _572_/A _571_/B VGND VGND VPWR VPWR _571_/X sky130_fd_sc_hd__or2_4
X_640_ _638_/A _638_/B _639_/Y VGND VGND VPWR VPWR _640_/Y sky130_fd_sc_hd__a21oi_2
XFILLER_16_115 VGND VGND VPWR VPWR sky130_fd_sc_hd__decap_3
XTAP_TAPCELL_ROW_26_165 VGND VPWR sky130_fd_sc_hd__tapvpwrvgnd_1
XFILLER_21_81 VGND VGND VPWR VPWR sky130_fd_sc_hd__decap_3
XTAP_TAPCELL_ROW_17_132 VGND VPWR sky130_fd_sc_hd__tapvpwrvgnd_1
XFILLER_7_61 VGND VGND VPWR VPWR sky130_fd_sc_hd__fill_1
XFILLER_26_59 VGND VGND VPWR VPWR sky130_fd_sc_hd__fill_2
XFILLER_21_140 VGND VGND VPWR VPWR sky130_fd_sc_hd__decap_3
XTAP_TAPCELL_ROW_8_100 VGND VPWR sky130_fd_sc_hd__tapvpwrvgnd_1
X_485_ _500_/B _485_/B VGND VGND VPWR VPWR _485_/Y sky130_fd_sc_hd__xnor2_4
X_554_ _553_/A _553_/B _649_/Y VGND VGND VPWR VPWR _555_/B sky130_fd_sc_hd__a21oi_4
X_623_ _623_/A _623_/B _623_/C _623_/D VGND VGND VPWR VPWR _624_/A sky130_fd_sc_hd__nand4_4
XFILLER_16_70 VGND VGND VPWR VPWR sky130_fd_sc_hd__decap_3
XFILLER_8_177 VGND VGND VPWR VPWR sky130_fd_sc_hd__fill_1
XTAP_TAPCELL_ROW_3_84 VGND VPWR sky130_fd_sc_hd__tapvpwrvgnd_1
XFILLER_5_147 VGND VGND VPWR VPWR sky130_fd_sc_hd__decap_3
X_468_ _470_/C _470_/A _587_/Y VGND VGND VPWR VPWR _471_/A sky130_fd_sc_hd__o21a_2
X_537_ _525_/Y _536_/A _532_/A _532_/B VGND VGND VPWR VPWR _537_/Y sky130_fd_sc_hd__o2bb2ai_4
X_606_ _604_/Y _605_/C _602_/Y VGND VGND VPWR VPWR _623_/B sky130_fd_sc_hd__a21oi_4
X_399_ _397_/B _585_/A _399_/C VGND VGND VPWR VPWR _409_/D sky130_fd_sc_hd__nand3b_2
XFILLER_4_51 VGND VGND VPWR VPWR sky130_fd_sc_hd__fill_2
XFILLER_23_38 VGND VGND VPWR VPWR sky130_fd_sc_hd__decap_3
X_322_ _320_/Y _319_/X input1/X VGND VGND VPWR VPWR _322_/Y sky130_fd_sc_hd__o21bai_4
XPHY_EDGE_ROW_24_Left_58 VGND VGND VPWR VPWR sky130_fd_sc_hd__decap_3
XFILLER_13_93 VGND VGND VPWR VPWR sky130_fd_sc_hd__decap_3
XTAP_TAPCELL_ROW_0_74 VGND VPWR sky130_fd_sc_hd__tapvpwrvgnd_1
XFILLER_24_70 VGND VGND VPWR VPWR sky130_fd_sc_hd__decap_3
XFILLER_1_52 VGND VGND VPWR VPWR sky130_fd_sc_hd__decap_3
XFILLER_29_26 VGND VGND VPWR VPWR sky130_fd_sc_hd__decap_3
XFILLER_28_179 VGND VGND VPWR VPWR sky130_fd_sc_hd__decap_3
XFILLER_28_146 VGND VGND VPWR VPWR sky130_fd_sc_hd__decap_3
XTAP_TAPCELL_ROW_29_174 VGND VPWR sky130_fd_sc_hd__tapvpwrvgnd_1
XFILLER_19_146 VGND VGND VPWR VPWR sky130_fd_sc_hd__decap_3
XTAP_TAPCELL_ROW_6_95 VGND VPWR sky130_fd_sc_hd__tapvpwrvgnd_1
XPHY_EDGE_ROW_27_Left_61 VGND VGND VPWR VPWR sky130_fd_sc_hd__decap_3
XPHY_EDGE_ROW_11_Left_45 VGND VGND VPWR VPWR sky130_fd_sc_hd__decap_3
XFILLER_25_149 VGND VGND VPWR VPWR sky130_fd_sc_hd__fill_1
XFILLER_25_116 VGND VGND VPWR VPWR sky130_fd_sc_hd__decap_3
XFILLER_15_39 VGND VGND VPWR VPWR sky130_fd_sc_hd__decap_3
X_570_ _570_/A _570_/B VGND VGND VPWR VPWR _570_/X sky130_fd_sc_hd__xor2_2
XFILLER_16_127 VGND VGND VPWR VPWR sky130_fd_sc_hd__decap_3
XFILLER_24_193 VGND VGND VPWR VPWR sky130_fd_sc_hd__decap_3
XFILLER_21_93 VGND VGND VPWR VPWR sky130_fd_sc_hd__decap_3
XTAP_TAPCELL_ROW_17_133 VGND VPWR sky130_fd_sc_hd__tapvpwrvgnd_1
XFILLER_22_119 VGND VGND VPWR VPWR sky130_fd_sc_hd__decap_3
XFILLER_30_174 VGND VGND VPWR VPWR sky130_fd_sc_hd__fill_2
XPHY_EDGE_ROW_15_Right_15 VGND VGND VPWR VPWR sky130_fd_sc_hd__decap_3
XPHY_EDGE_ROW_24_Right_24 VGND VGND VPWR VPWR sky130_fd_sc_hd__decap_3
XFILLER_21_152 VGND VGND VPWR VPWR sky130_fd_sc_hd__decap_3
XFILLER_13_119 VGND VGND VPWR VPWR sky130_fd_sc_hd__decap_3
XFILLER_13_108 VGND VGND VPWR VPWR sky130_fd_sc_hd__decap_3
XTAP_TAPCELL_ROW_8_101 VGND VPWR sky130_fd_sc_hd__tapvpwrvgnd_1
XTAP_TAPCELL_ROW_31_180 VGND VPWR sky130_fd_sc_hd__tapvpwrvgnd_1
XPHY_EDGE_ROW_33_Right_33 VGND VGND VPWR VPWR sky130_fd_sc_hd__decap_3
X_622_ _611_/Y _609_/Y _613_/Y VGND VGND VPWR VPWR _623_/D sky130_fd_sc_hd__a21oi_4
X_484_ _500_/A _478_/B _486_/B VGND VGND VPWR VPWR _485_/B sky130_fd_sc_hd__o21ai_4
X_553_ _553_/A _553_/B VGND VGND VPWR VPWR _553_/X sky130_fd_sc_hd__xor2_2
XFILLER_16_82 VGND VGND VPWR VPWR sky130_fd_sc_hd__fill_2
XFILLER_8_145 VGND VGND VPWR VPWR sky130_fd_sc_hd__fill_2
XFILLER_12_163 VGND VGND VPWR VPWR sky130_fd_sc_hd__fill_1
XFILLER_12_141 VGND VGND VPWR VPWR sky130_fd_sc_hd__fill_2
XFILLER_26_200 VGND VGND VPWR VPWR sky130_fd_sc_hd__fill_2
XFILLER_5_159 VGND VGND VPWR VPWR sky130_fd_sc_hd__decap_3
X_605_ input2/X _605_/B _605_/C VGND VGND VPWR VPWR _605_/Y sky130_fd_sc_hd__nand3b_4
X_467_ _490_/A _467_/B VGND VGND VPWR VPWR _470_/A sky130_fd_sc_hd__nor2_2
X_536_ _536_/A _536_/B VGND VGND VPWR VPWR _536_/X sky130_fd_sc_hd__and2_2
X_398_ _397_/A _397_/B _585_/Y VGND VGND VPWR VPWR _409_/C sky130_fd_sc_hd__o21ai_2
XFILLER_4_85 VGND VGND VPWR VPWR sky130_fd_sc_hd__decap_3
XFILLER_4_192 VGND VGND VPWR VPWR sky130_fd_sc_hd__decap_3
XFILLER_3_9 VGND VGND VPWR VPWR sky130_fd_sc_hd__decap_3
X_321_ _319_/A _547_/S input1/X VGND VGND VPWR VPWR _321_/Y sky130_fd_sc_hd__o21ai_4
XFILLER_13_72 VGND VGND VPWR VPWR sky130_fd_sc_hd__decap_3
X_519_ _519_/A _525_/A VGND VGND VPWR VPWR _519_/Y sky130_fd_sc_hd__xnor2_2
XFILLER_1_6 VGND VGND VPWR VPWR sky130_fd_sc_hd__decap_3
XFILLER_24_82 VGND VGND VPWR VPWR sky130_fd_sc_hd__fill_2
XFILLER_20_29 VGND VGND VPWR VPWR sky130_fd_sc_hd__decap_3
XFILLER_20_18 VGND VGND VPWR VPWR sky130_fd_sc_hd__fill_1
XFILLER_28_158 VGND VGND VPWR VPWR sky130_fd_sc_hd__decap_3
XFILLER_28_136 VGND VGND VPWR VPWR sky130_fd_sc_hd__decap_3
XFILLER_28_125 VGND VGND VPWR VPWR sky130_fd_sc_hd__decap_3
XFILLER_10_51 VGND VGND VPWR VPWR sky130_fd_sc_hd__decap_3
XFILLER_19_60 VGND VGND VPWR VPWR sky130_fd_sc_hd__decap_3
XFILLER_19_125 VGND VGND VPWR VPWR sky130_fd_sc_hd__decap_3
XFILLER_10_95 VGND VGND VPWR VPWR sky130_fd_sc_hd__decap_3
XTAP_TAPCELL_ROW_29_175 VGND VPWR sky130_fd_sc_hd__tapvpwrvgnd_1
XFILLER_32_3 VGND VGND VPWR VPWR sky130_fd_sc_hd__fill_2
XFILLER_25_128 VGND VGND VPWR VPWR sky130_fd_sc_hd__decap_3
XFILLER_33_194 VGND VGND VPWR VPWR sky130_fd_sc_hd__fill_2
XFILLER_24_172 VGND VGND VPWR VPWR sky130_fd_sc_hd__decap_3
XFILLER_24_150 VGND VGND VPWR VPWR sky130_fd_sc_hd__fill_2
XFILLER_16_139 VGND VGND VPWR VPWR sky130_fd_sc_hd__fill_1
XFILLER_16_106 VGND VGND VPWR VPWR sky130_fd_sc_hd__decap_3
XFILLER_21_72 VGND VGND VPWR VPWR sky130_fd_sc_hd__decap_3
XFILLER_15_172 VGND VGND VPWR VPWR sky130_fd_sc_hd__fill_1
XFILLER_7_74 VGND VGND VPWR VPWR sky130_fd_sc_hd__fill_1
XFILLER_30_197 VGND VGND VPWR VPWR sky130_fd_sc_hd__decap_3
XFILLER_30_186 VGND VGND VPWR VPWR sky130_fd_sc_hd__fill_1
XTAP_TAPCELL_ROW_31_181 VGND VPWR sky130_fd_sc_hd__tapvpwrvgnd_1
XFILLER_21_164 VGND VGND VPWR VPWR sky130_fd_sc_hd__decap_3
XFILLER_21_131 VGND VGND VPWR VPWR sky130_fd_sc_hd__decap_3
XTAP_TAPCELL_ROW_8_102 VGND VPWR sky130_fd_sc_hd__tapvpwrvgnd_1
X_621_ _620_/Y _614_/Y _616_/Y VGND VGND VPWR VPWR _623_/C sky130_fd_sc_hd__a21oi_4
X_483_ _486_/C _487_/B VGND VGND VPWR VPWR _500_/B sky130_fd_sc_hd__nand2_2
X_552_ _552_/A _552_/B VGND VGND VPWR VPWR _552_/X sky130_fd_sc_hd__xor2_2
XFILLER_16_94 VGND VGND VPWR VPWR sky130_fd_sc_hd__decap_3
XFILLER_16_61 VGND VGND VPWR VPWR sky130_fd_sc_hd__decap_3
XFILLER_12_197 VGND VGND VPWR VPWR sky130_fd_sc_hd__decap_3
X_535_ _536_/A _525_/Y _531_/X _533_/Y VGND VGND VPWR VPWR _538_/B sky130_fd_sc_hd__a211oi_4
X_604_ _625_/A _598_/B input2/X VGND VGND VPWR VPWR _604_/Y sky130_fd_sc_hd__a21oi_2
XFILLER_27_60 VGND VGND VPWR VPWR sky130_fd_sc_hd__decap_3
X_466_ _490_/A _467_/B VGND VGND VPWR VPWR _470_/C sky130_fd_sc_hd__and2_4
X_397_ _397_/A _397_/B VGND VGND VPWR VPWR _397_/Y sky130_fd_sc_hd__nor2_2
XFILLER_23_29 VGND VGND VPWR VPWR sky130_fd_sc_hd__decap_3
X_320_ _547_/S _320_/B VGND VGND VPWR VPWR _320_/Y sky130_fd_sc_hd__nor2_4
XFILLER_13_40 VGND VGND VPWR VPWR sky130_fd_sc_hd__decap_3
XFILLER_13_84 VGND VGND VPWR VPWR sky130_fd_sc_hd__decap_3
XFILLER_1_185 VGND VGND VPWR VPWR sky130_fd_sc_hd__decap_3
X_518_ _518_/A VGND VGND VPWR VPWR _525_/A sky130_fd_sc_hd__inv_2
X_449_ _446_/A _446_/B _447_/C VGND VGND VPWR VPWR _463_/B sky130_fd_sc_hd__o21bai_4
XFILLER_18_29 VGND VGND VPWR VPWR sky130_fd_sc_hd__decap_3
XFILLER_6_200 VGND VGND VPWR VPWR sky130_fd_sc_hd__fill_2
XFILLER_24_61 VGND VGND VPWR VPWR sky130_fd_sc_hd__fill_1
XFILLER_28_104 VGND VGND VPWR VPWR sky130_fd_sc_hd__decap_3
XFILLER_10_63 VGND VGND VPWR VPWR sky130_fd_sc_hd__decap_3
XFILLER_19_50 VGND VGND VPWR VPWR sky130_fd_sc_hd__decap_3
XFILLER_19_137 VGND VGND VPWR VPWR sky130_fd_sc_hd__decap_3
XFILLER_31_29 VGND VGND VPWR VPWR sky130_fd_sc_hd__decap_3
XFILLER_16_118 VGND VGND VPWR VPWR sky130_fd_sc_hd__decap_3
XFILLER_21_84 VGND VGND VPWR VPWR sky130_fd_sc_hd__fill_1
XFILLER_7_20 VGND VGND VPWR VPWR sky130_fd_sc_hd__fill_2
XFILLER_15_140 VGND VGND VPWR VPWR sky130_fd_sc_hd__decap_3
XFILLER_7_97 VGND VGND VPWR VPWR sky130_fd_sc_hd__decap_3
XPHY_EDGE_ROW_5_Right_5 VGND VGND VPWR VPWR sky130_fd_sc_hd__decap_3
XFILLER_26_29 VGND VGND VPWR VPWR sky130_fd_sc_hd__decap_3
XTAP_TAPCELL_ROW_31_182 VGND VPWR sky130_fd_sc_hd__tapvpwrvgnd_1
XFILLER_21_143 VGND VGND VPWR VPWR sky130_fd_sc_hd__decap_3
X_551_ _584_/Y _336_/Y _343_/X _324_/Y VGND VGND VPWR VPWR _552_/A sky130_fd_sc_hd__a22oi_2
X_620_ _625_/A _620_/A2 _620_/B1 VGND VGND VPWR VPWR _620_/Y sky130_fd_sc_hd__a21oi_2
X_482_ _481_/A _481_/B input18/X VGND VGND VPWR VPWR _487_/B sky130_fd_sc_hd__o21bai_2
XFILLER_16_73 VGND VGND VPWR VPWR sky130_fd_sc_hd__decap_3
XFILLER_12_110 VGND VGND VPWR VPWR sky130_fd_sc_hd__decap_3
XFILLER_8_158 VGND VGND VPWR VPWR sky130_fd_sc_hd__fill_2
XFILLER_7_191 VGND VGND VPWR VPWR sky130_fd_sc_hd__decap_3
X_465_ _472_/C _465_/B VGND VGND VPWR VPWR _465_/X sky130_fd_sc_hd__xor2_2
X_534_ _531_/X _533_/Y _536_/A _525_/Y VGND VGND VPWR VPWR _538_/A sky130_fd_sc_hd__o211a_4
X_603_ _603_/A _603_/B VGND VGND VPWR VPWR _603_/Y sky130_fd_sc_hd__nand2_2
X_396_ _529_/A _396_/B VGND VGND VPWR VPWR _397_/B sky130_fd_sc_hd__nor2_2
XFILLER_13_63 VGND VGND VPWR VPWR sky130_fd_sc_hd__decap_3
XFILLER_13_96 VGND VGND VPWR VPWR sky130_fd_sc_hd__decap_3
X_448_ _447_/A _447_/B _447_/C VGND VGND VPWR VPWR _448_/Y sky130_fd_sc_hd__a21oi_2
X_517_ _588_/A _517_/B VGND VGND VPWR VPWR _518_/A sky130_fd_sc_hd__xor2_2
X_379_ _380_/D _572_/A _576_/A _578_/A VGND VGND VPWR VPWR _379_/Y sky130_fd_sc_hd__nor4_2
XFILLER_24_95 VGND VGND VPWR VPWR sky130_fd_sc_hd__decap_3
XFILLER_24_73 VGND VGND VPWR VPWR sky130_fd_sc_hd__decap_3
XFILLER_1_55 VGND VGND VPWR VPWR sky130_fd_sc_hd__fill_1
XFILLER_29_29 VGND VGND VPWR VPWR sky130_fd_sc_hd__fill_2
XFILLER_28_149 VGND VGND VPWR VPWR sky130_fd_sc_hd__decap_3
XFILLER_19_73 VGND VGND VPWR VPWR sky130_fd_sc_hd__decap_3
XFILLER_19_149 VGND VGND VPWR VPWR sky130_fd_sc_hd__fill_1
XFILLER_18_3 VGND VGND VPWR VPWR sky130_fd_sc_hd__decap_3
XFILLER_25_119 VGND VGND VPWR VPWR sky130_fd_sc_hd__decap_3
XFILLER_24_141 VGND VGND VPWR VPWR sky130_fd_sc_hd__decap_3
XFILLER_24_130 VGND VGND VPWR VPWR sky130_fd_sc_hd__decap_3
XFILLER_21_96 VGND VGND VPWR VPWR sky130_fd_sc_hd__decap_3
XFILLER_21_30 VGND VGND VPWR VPWR sky130_fd_sc_hd__decap_3
XFILLER_30_122 VGND VGND VPWR VPWR sky130_fd_sc_hd__fill_2
XPHY_EDGE_ROW_15_Left_49 VGND VGND VPWR VPWR sky130_fd_sc_hd__decap_3
XFILLER_21_122 VGND VGND VPWR VPWR sky130_fd_sc_hd__decap_3
XFILLER_21_111 VGND VGND VPWR VPWR sky130_fd_sc_hd__fill_1
XFILLER_21_199 VGND VGND VPWR VPWR sky130_fd_sc_hd__decap_3
XFILLER_21_155 VGND VGND VPWR VPWR sky130_fd_sc_hd__decap_3
X_481_ _481_/A _481_/B input18/X VGND VGND VPWR VPWR _486_/C sky130_fd_sc_hd__or3b_4
X_550_ _550_/A _550_/B VGND VGND VPWR VPWR _550_/X sky130_fd_sc_hd__xor2_2
XTAP_TAPCELL_ROW_22_150 VGND VPWR sky130_fd_sc_hd__tapvpwrvgnd_1
XPHY_EDGE_ROW_11_Right_11 VGND VGND VPWR VPWR sky130_fd_sc_hd__decap_3
XFILLER_16_85 VGND VGND VPWR VPWR sky130_fd_sc_hd__decap_3
XFILLER_12_122 VGND VGND VPWR VPWR sky130_fd_sc_hd__fill_1
XFILLER_12_100 VGND VGND VPWR VPWR sky130_fd_sc_hd__decap_3
XPHY_EDGE_ROW_20_Right_20 VGND VGND VPWR VPWR sky130_fd_sc_hd__decap_3
XFILLER_5_107 VGND VGND VPWR VPWR sky130_fd_sc_hd__decap_3
X_602_ _602_/A1 _598_/B _601_/Y VGND VGND VPWR VPWR _602_/Y sky130_fd_sc_hd__a21oi_4
X_464_ _448_/Y _462_/Y _433_/A _463_/X VGND VGND VPWR VPWR _465_/B sky130_fd_sc_hd__a2bb2oi_2
X_533_ _531_/A _531_/B _532_/A VGND VGND VPWR VPWR _533_/Y sky130_fd_sc_hd__a21oi_2
X_395_ _529_/A _396_/B VGND VGND VPWR VPWR _399_/C sky130_fd_sc_hd__nand2_2
XFILLER_4_195 VGND VGND VPWR VPWR sky130_fd_sc_hd__fill_1
XPHY_EDGE_ROW_18_Left_52 VGND VGND VPWR VPWR sky130_fd_sc_hd__decap_3
XFILLER_13_75 VGND VGND VPWR VPWR sky130_fd_sc_hd__decap_3
X_447_ _447_/A _447_/B _447_/C VGND VGND VPWR VPWR _463_/C sky130_fd_sc_hd__nand3_2
X_516_ _521_/A _516_/B VGND VGND VPWR VPWR _517_/B sky130_fd_sc_hd__xnor2_2
X_378_ _384_/A _378_/B VGND VGND VPWR VPWR _578_/A sky130_fd_sc_hd__nand2_4
XPHY_EDGE_ROW_3_Left_37 VGND VGND VPWR VPWR sky130_fd_sc_hd__decap_3
XFILLER_1_9 VGND VGND VPWR VPWR sky130_fd_sc_hd__decap_3
XFILLER_24_85 VGND VGND VPWR VPWR sky130_fd_sc_hd__fill_1
XFILLER_24_52 VGND VGND VPWR VPWR sky130_fd_sc_hd__decap_3
XFILLER_1_12 VGND VGND VPWR VPWR sky130_fd_sc_hd__decap_3
XFILLER_1_67 VGND VGND VPWR VPWR sky130_fd_sc_hd__fill_1
XFILLER_28_139 VGND VGND VPWR VPWR sky130_fd_sc_hd__fill_1
XFILLER_10_98 VGND VGND VPWR VPWR sky130_fd_sc_hd__decap_3
XFILLER_10_54 VGND VGND VPWR VPWR sky130_fd_sc_hd__decap_3
XFILLER_19_63 VGND VGND VPWR VPWR sky130_fd_sc_hd__fill_1
XFILLER_19_41 VGND VGND VPWR VPWR sky130_fd_sc_hd__decap_3
XFILLER_19_128 VGND VGND VPWR VPWR sky130_fd_sc_hd__decap_3
XFILLER_33_197 VGND VGND VPWR VPWR sky130_fd_sc_hd__decap_3
XFILLER_16_109 VGND VGND VPWR VPWR sky130_fd_sc_hd__decap_3
XFILLER_24_197 VGND VGND VPWR VPWR sky130_fd_sc_hd__decap_3
XFILLER_24_175 VGND VGND VPWR VPWR sky130_fd_sc_hd__fill_1
XFILLER_21_75 VGND VGND VPWR VPWR sky130_fd_sc_hd__decap_3
XPHY_EDGE_ROW_6_Left_40 VGND VGND VPWR VPWR sky130_fd_sc_hd__decap_3
XFILLER_15_131 VGND VGND VPWR VPWR sky130_fd_sc_hd__decap_3
XFILLER_7_55 VGND VGND VPWR VPWR sky130_fd_sc_hd__fill_1
XFILLER_21_167 VGND VGND VPWR VPWR sky130_fd_sc_hd__fill_1
XFILLER_21_134 VGND VGND VPWR VPWR sky130_fd_sc_hd__decap_3
X_480_ _490_/A _480_/B VGND VGND VPWR VPWR _481_/B sky130_fd_sc_hd__and2_2
XPHY_EDGE_ROW_32_Left_66 VGND VGND VPWR VPWR sky130_fd_sc_hd__decap_3
XFILLER_16_64 VGND VGND VPWR VPWR sky130_fd_sc_hd__decap_3
XTAP_TAPCELL_ROW_22_151 VGND VPWR sky130_fd_sc_hd__tapvpwrvgnd_1
XFILLER_16_97 VGND VGND VPWR VPWR sky130_fd_sc_hd__decap_3
X_601_ _599_/B _598_/B input2/X VGND VGND VPWR VPWR _601_/Y sky130_fd_sc_hd__o21ai_4
XFILLER_27_63 VGND VGND VPWR VPWR sky130_fd_sc_hd__decap_3
XFILLER_27_52 VGND VGND VPWR VPWR sky130_fd_sc_hd__decap_3
X_463_ _463_/A _463_/B _463_/C VGND VGND VPWR VPWR _463_/X sky130_fd_sc_hd__and3_2
X_532_ _532_/A _532_/B VGND VGND VPWR VPWR _536_/B sky130_fd_sc_hd__nand2_2
X_394_ _529_/A _396_/B VGND VGND VPWR VPWR _397_/A sky130_fd_sc_hd__and2_2
XFILLER_13_87 VGND VGND VPWR VPWR sky130_fd_sc_hd__decap_3
XFILLER_13_43 VGND VGND VPWR VPWR sky130_fd_sc_hd__decap_3
XTAP_TAPCELL_ROW_0_68 VGND VPWR sky130_fd_sc_hd__tapvpwrvgnd_1
XFILLER_8_3 VGND VGND VPWR VPWR sky130_fd_sc_hd__decap_3
XFILLER_1_188 VGND VGND VPWR VPWR sky130_fd_sc_hd__fill_1
X_515_ _385_/Y _513_/X _511_/Y VGND VGND VPWR VPWR _525_/B sky130_fd_sc_hd__o21bai_4
X_446_ _446_/A _446_/B VGND VGND VPWR VPWR _446_/Y sky130_fd_sc_hd__nor2_2
X_377_ _375_/C _375_/A _375_/B VGND VGND VPWR VPWR _378_/B sky130_fd_sc_hd__a21o_2
XFILLER_1_57 VGND VGND VPWR VPWR sky130_fd_sc_hd__fill_1
X_429_ _429_/A _429_/B VGND VGND VPWR VPWR _429_/Y sky130_fd_sc_hd__nor2_2
Xinput1 A[0] VGND VGND VPWR VPWR input1/X sky130_fd_sc_hd__clkdlybuf4s25_1
XFILLER_28_107 VGND VGND VPWR VPWR sky130_fd_sc_hd__fill_1
XFILLER_19_53 VGND VGND VPWR VPWR sky130_fd_sc_hd__decap_3
XFILLER_10_66 VGND VGND VPWR VPWR sky130_fd_sc_hd__decap_3
XFILLER_18_195 VGND VGND VPWR VPWR sky130_fd_sc_hd__fill_1
XFILLER_24_121 VGND VGND VPWR VPWR sky130_fd_sc_hd__decap_3
XTAP_TAPCELL_ROW_25_160 VGND VPWR sky130_fd_sc_hd__tapvpwrvgnd_1
XFILLER_30_113 VGND VGND VPWR VPWR sky130_fd_sc_hd__decap_3
XFILLER_7_34 VGND VGND VPWR VPWR sky130_fd_sc_hd__decap_3
XFILLER_23_3 VGND VGND VPWR VPWR sky130_fd_sc_hd__fill_2
XFILLER_21_146 VGND VGND VPWR VPWR sky130_fd_sc_hd__decap_3
XFILLER_21_113 VGND VGND VPWR VPWR sky130_fd_sc_hd__decap_3
XFILLER_21_102 VGND VGND VPWR VPWR sky130_fd_sc_hd__decap_3
XFILLER_16_76 VGND VGND VPWR VPWR sky130_fd_sc_hd__decap_3
XFILLER_16_32 VGND VGND VPWR VPWR sky130_fd_sc_hd__fill_2
XFILLER_12_113 VGND VGND VPWR VPWR sky130_fd_sc_hd__decap_3
XPHY_EDGE_ROW_9_Right_9 VGND VGND VPWR VPWR sky130_fd_sc_hd__decap_3
X_531_ _531_/A _531_/B _532_/A VGND VGND VPWR VPWR _531_/X sky130_fd_sc_hd__and3_2
X_600_ _597_/A _598_/B input2/X VGND VGND VPWR VPWR _603_/A sky130_fd_sc_hd__o21a_2
XFILLER_27_31 VGND VGND VPWR VPWR sky130_fd_sc_hd__decap_3
X_462_ _447_/C _446_/Y _451_/Y _452_/D VGND VGND VPWR VPWR _462_/Y sky130_fd_sc_hd__a22oi_2
X_393_ _425_/A _393_/B VGND VGND VPWR VPWR _393_/Y sky130_fd_sc_hd__xnor2_2
XFILLER_13_22 VGND VGND VPWR VPWR sky130_fd_sc_hd__fill_1
XFILLER_13_99 VGND VGND VPWR VPWR sky130_fd_sc_hd__decap_3
XFILLER_13_66 VGND VGND VPWR VPWR sky130_fd_sc_hd__decap_3
XTAP_TAPCELL_ROW_0_69 VGND VPWR sky130_fd_sc_hd__tapvpwrvgnd_1
XFILLER_1_145 VGND VGND VPWR VPWR sky130_fd_sc_hd__fill_1
X_514_ _393_/B _512_/Y _514_/B1 VGND VGND VPWR VPWR _519_/A sky130_fd_sc_hd__a21oi_4
X_445_ _490_/A _445_/B VGND VGND VPWR VPWR _447_/B sky130_fd_sc_hd__nand2_2
X_376_ _375_/C _375_/A _375_/B VGND VGND VPWR VPWR _376_/Y sky130_fd_sc_hd__a21oi_2
XFILLER_24_98 VGND VGND VPWR VPWR sky130_fd_sc_hd__decap_3
XFILLER_24_76 VGND VGND VPWR VPWR sky130_fd_sc_hd__decap_3
XFILLER_24_32 VGND VGND VPWR VPWR sky130_fd_sc_hd__fill_1
XFILLER_10_200 VGND VGND VPWR VPWR sky130_fd_sc_hd__fill_2
X_428_ _428_/A _429_/B VGND VGND VPWR VPWR _430_/C sky130_fd_sc_hd__nand2_2
X_359_ _359_/A _359_/B _359_/C VGND VGND VPWR VPWR _360_/A sky130_fd_sc_hd__nand3_4
Xinput2 A[10] VGND VGND VPWR VPWR input2/X sky130_fd_sc_hd__clkdlybuf4s25_1
XFILLER_10_45 VGND VGND VPWR VPWR sky130_fd_sc_hd__decap_3
XFILLER_19_76 VGND VGND VPWR VPWR sky130_fd_sc_hd__decap_3
XFILLER_18_6 VGND VGND VPWR VPWR sky130_fd_sc_hd__fill_1
XFILLER_18_141 VGND VGND VPWR VPWR sky130_fd_sc_hd__decap_3
XFILLER_18_130 VGND VGND VPWR VPWR sky130_fd_sc_hd__decap_3
XFILLER_24_144 VGND VGND VPWR VPWR sky130_fd_sc_hd__fill_1
XFILLER_24_133 VGND VGND VPWR VPWR sky130_fd_sc_hd__decap_3
XFILLER_21_33 VGND VGND VPWR VPWR sky130_fd_sc_hd__decap_3
XFILLER_21_99 VGND VGND VPWR VPWR sky130_fd_sc_hd__decap_3
XTAP_TAPCELL_ROW_25_161 VGND VPWR sky130_fd_sc_hd__tapvpwrvgnd_1
XFILLER_15_166 VGND VGND VPWR VPWR sky130_fd_sc_hd__fill_2
XFILLER_15_122 VGND VGND VPWR VPWR sky130_fd_sc_hd__decap_3
XFILLER_15_111 VGND VGND VPWR VPWR sky130_fd_sc_hd__fill_1
XFILLER_16_3 VGND VGND VPWR VPWR sky130_fd_sc_hd__fill_2
XFILLER_21_158 VGND VGND VPWR VPWR sky130_fd_sc_hd__decap_3
XFILLER_21_125 VGND VGND VPWR VPWR sky130_fd_sc_hd__decap_3
Xinput60 B[5] VGND VGND VPWR VPWR _638_/B sky130_fd_sc_hd__clkdlybuf4s25_1
XFILLER_8_118 VGND VGND VPWR VPWR sky130_fd_sc_hd__fill_1
XFILLER_16_88 VGND VGND VPWR VPWR sky130_fd_sc_hd__decap_3
XFILLER_12_103 VGND VGND VPWR VPWR sky130_fd_sc_hd__fill_2
X_461_ _461_/A _461_/B VGND VGND VPWR VPWR _472_/C sky130_fd_sc_hd__nand2_2
X_530_ _531_/A _531_/B VGND VGND VPWR VPWR _532_/B sky130_fd_sc_hd__and2_2
X_392_ _409_/A _409_/B VGND VGND VPWR VPWR _425_/A sky130_fd_sc_hd__nand2_2
XFILLER_4_121 VGND VGND VPWR VPWR sky130_fd_sc_hd__fill_2
XFILLER_1_113 VGND VGND VPWR VPWR sky130_fd_sc_hd__decap_3
XFILLER_13_78 VGND VGND VPWR VPWR sky130_fd_sc_hd__decap_3
X_444_ _444_/A _445_/B VGND VGND VPWR VPWR _446_/B sky130_fd_sc_hd__and2_2
X_513_ _513_/A _513_/B VGND VGND VPWR VPWR _513_/X sky130_fd_sc_hd__or2_4
X_375_ _375_/A _375_/B _375_/C VGND VGND VPWR VPWR _384_/A sky130_fd_sc_hd__nand3_4
XFILLER_24_55 VGND VGND VPWR VPWR sky130_fd_sc_hd__decap_3
XFILLER_1_15 VGND VGND VPWR VPWR sky130_fd_sc_hd__fill_1
X_427_ _429_/A _429_/B VGND VGND VPWR VPWR _427_/X sky130_fd_sc_hd__and2_4
X_358_ _353_/X _355_/Y _359_/B VGND VGND VPWR VPWR _360_/B sky130_fd_sc_hd__o21bai_2
XPHY_EDGE_ROW_18_Right_18 VGND VGND VPWR VPWR sky130_fd_sc_hd__decap_3
Xinput3 A[11] VGND VGND VPWR VPWR _581_/A sky130_fd_sc_hd__clkdlybuf4s25_1
XPHY_EDGE_ROW_27_Right_27 VGND VGND VPWR VPWR sky130_fd_sc_hd__decap_3
XFILLER_10_57 VGND VGND VPWR VPWR sky130_fd_sc_hd__decap_3
XFILLER_19_44 VGND VGND VPWR VPWR sky130_fd_sc_hd__decap_3
XTAP_TAPCELL_ROW_28_170 VGND VPWR sky130_fd_sc_hd__tapvpwrvgnd_1
XFILLER_18_197 VGND VGND VPWR VPWR sky130_fd_sc_hd__decap_3
XFILLER_24_101 VGND VGND VPWR VPWR sky130_fd_sc_hd__decap_3
XFILLER_21_78 VGND VGND VPWR VPWR sky130_fd_sc_hd__decap_3
XFILLER_15_134 VGND VGND VPWR VPWR sky130_fd_sc_hd__decap_3
Xinput50 B[25] VGND VGND VPWR VPWR _480_/B sky130_fd_sc_hd__clkdlybuf4s25_1
Xinput61 B[6] VGND VGND VPWR VPWR _632_/B sky130_fd_sc_hd__clkdlybuf4s25_1
XFILLER_21_137 VGND VGND VPWR VPWR sky130_fd_sc_hd__decap_3
XPHY_EDGE_ROW_0_Right_0 VGND VGND VPWR VPWR sky130_fd_sc_hd__decap_3
XFILLER_16_67 VGND VGND VPWR VPWR sky130_fd_sc_hd__decap_3
XFILLER_20_170 VGND VGND VPWR VPWR sky130_fd_sc_hd__decap_3
XFILLER_11_192 VGND VGND VPWR VPWR sky130_fd_sc_hd__fill_2
X_460_ _586_/Y _460_/B _460_/C VGND VGND VPWR VPWR _461_/B sky130_fd_sc_hd__nand3_2
X_391_ _387_/X _389_/Y _390_/B VGND VGND VPWR VPWR _409_/B sky130_fd_sc_hd__o21bai_2
XFILLER_27_88 VGND VGND VPWR VPWR sky130_fd_sc_hd__decap_3
XFILLER_27_66 VGND VGND VPWR VPWR sky130_fd_sc_hd__fill_2
XFILLER_27_55 VGND VGND VPWR VPWR sky130_fd_sc_hd__fill_1
XFILLER_27_22 VGND VGND VPWR VPWR sky130_fd_sc_hd__decap_3
X_589_ _589_/A VGND VGND VPWR VPWR _589_/Y sky130_fd_sc_hd__inv_2
X_658_ _314_/B _658_/B VGND VGND VPWR VPWR _658_/Y sky130_fd_sc_hd__nand2b_2
XFILLER_13_57 VGND VGND VPWR VPWR sky130_fd_sc_hd__fill_1
XFILLER_13_46 VGND VGND VPWR VPWR sky130_fd_sc_hd__decap_3
XFILLER_8_6 VGND VGND VPWR VPWR sky130_fd_sc_hd__fill_1
X_443_ _490_/A _445_/B VGND VGND VPWR VPWR _447_/A sky130_fd_sc_hd__or2_4
X_512_ _513_/A _513_/B VGND VGND VPWR VPWR _512_/Y sky130_fd_sc_hd__nor2_2
X_374_ _374_/A _529_/A VGND VGND VPWR VPWR _375_/A sky130_fd_sc_hd__or2_4
X_426_ _385_/Y _425_/X _424_/Y VGND VGND VPWR VPWR _433_/A sky130_fd_sc_hd__o21bai_4
X_357_ _359_/C _359_/A _359_/B VGND VGND VPWR VPWR _357_/Y sky130_fd_sc_hd__a21oi_2
XPHY_EDGE_ROW_23_Left_57 VGND VGND VPWR VPWR sky130_fd_sc_hd__decap_3
Xinput4 A[12] VGND VGND VPWR VPWR _364_/B sky130_fd_sc_hd__clkdlybuf4s25_1
XFILLER_10_69 VGND VGND VPWR VPWR sky130_fd_sc_hd__fill_1
XTAP_TAPCELL_ROW_28_171 VGND VPWR sky130_fd_sc_hd__tapvpwrvgnd_1
XFILLER_33_157 VGND VGND VPWR VPWR sky130_fd_sc_hd__fill_2
XFILLER_18_121 VGND VGND VPWR VPWR sky130_fd_sc_hd__decap_3
X_409_ _409_/A _409_/B _409_/C _409_/D VGND VGND VPWR VPWR _419_/B sky130_fd_sc_hd__nand4_2
XFILLER_24_124 VGND VGND VPWR VPWR sky130_fd_sc_hd__decap_3
XFILLER_21_57 VGND VGND VPWR VPWR sky130_fd_sc_hd__fill_1
Xmax_cap99 _500_/D VGND VGND VPWR VPWR _478_/B sky130_fd_sc_hd__buf_6
XFILLER_15_113 VGND VGND VPWR VPWR sky130_fd_sc_hd__decap_3
XFILLER_15_102 VGND VGND VPWR VPWR sky130_fd_sc_hd__decap_3
XFILLER_30_116 VGND VGND VPWR VPWR sky130_fd_sc_hd__decap_3
XTAP_TAPCELL_ROW_16_130 VGND VPWR sky130_fd_sc_hd__tapvpwrvgnd_1
XPHY_EDGE_ROW_26_Left_60 VGND VGND VPWR VPWR sky130_fd_sc_hd__decap_3
XFILLER_21_149 VGND VGND VPWR VPWR sky130_fd_sc_hd__decap_3
XFILLER_21_116 VGND VGND VPWR VPWR sky130_fd_sc_hd__decap_3
XFILLER_21_105 VGND VGND VPWR VPWR sky130_fd_sc_hd__decap_3
Xinput40 B[16] VGND VGND VPWR VPWR _389_/A sky130_fd_sc_hd__clkdlybuf4s25_1
Xinput51 B[26] VGND VGND VPWR VPWR _490_/B sky130_fd_sc_hd__clkdlybuf4s25_1
Xinput62 B[7] VGND VGND VPWR VPWR _625_/B sky130_fd_sc_hd__clkdlybuf4s25_1
XPHY_EDGE_ROW_10_Left_44 VGND VGND VPWR VPWR sky130_fd_sc_hd__decap_3
XFILLER_16_46 VGND VGND VPWR VPWR sky130_fd_sc_hd__fill_2
XFILLER_16_79 VGND VGND VPWR VPWR sky130_fd_sc_hd__decap_3
XFILLER_12_116 VGND VGND VPWR VPWR sky130_fd_sc_hd__decap_3
Xrebuffer206 _341_/C VGND VGND VPWR VPWR rebuffer206/X sky130_fd_sc_hd__buf_6
XFILLER_8_91 VGND VGND VPWR VPWR sky130_fd_sc_hd__decap_3
XFILLER_27_34 VGND VGND VPWR VPWR sky130_fd_sc_hd__decap_3
XFILLER_27_12 VGND VGND VPWR VPWR sky130_fd_sc_hd__decap_3
X_390_ _389_/Y _390_/B _390_/C VGND VGND VPWR VPWR _409_/A sky130_fd_sc_hd__nand3b_2
XFILLER_4_101 VGND VGND VPWR VPWR sky130_fd_sc_hd__decap_3
XFILLER_4_27 VGND VGND VPWR VPWR sky130_fd_sc_hd__fill_1
X_657_ _657_/A _657_/B _657_/C _657_/D VGND VGND VPWR VPWR _657_/Y sky130_fd_sc_hd__nand4_4
X_588_ _588_/A VGND VGND VPWR VPWR _588_/Y sky130_fd_sc_hd__inv_2
XFILLER_22_200 VGND VGND VPWR VPWR sky130_fd_sc_hd__fill_2
XFILLER_13_69 VGND VGND VPWR VPWR sky130_fd_sc_hd__decap_3
XFILLER_1_159 VGND VGND VPWR VPWR sky130_fd_sc_hd__fill_1
X_511_ _474_/Y _513_/B _510_/Y VGND VGND VPWR VPWR _511_/Y sky130_fd_sc_hd__o21ai_2
X_442_ _444_/A _445_/B VGND VGND VPWR VPWR _446_/A sky130_fd_sc_hd__nor2_2
X_373_ _529_/A _374_/A VGND VGND VPWR VPWR _375_/C sky130_fd_sc_hd__nand2_2
XFILLER_13_200 VGND VGND VPWR VPWR sky130_fd_sc_hd__fill_2
XFILLER_24_79 VGND VGND VPWR VPWR sky130_fd_sc_hd__decap_3
XFILLER_24_46 VGND VGND VPWR VPWR sky130_fd_sc_hd__decap_3
XFILLER_24_24 VGND VGND VPWR VPWR sky130_fd_sc_hd__decap_3
X_425_ _425_/A _425_/B _425_/C _425_/D VGND VGND VPWR VPWR _425_/X sky130_fd_sc_hd__or4_4
X_356_ _363_/A _356_/B VGND VGND VPWR VPWR _359_/A sky130_fd_sc_hd__or2_4
Xinput5 A[13] VGND VGND VPWR VPWR _359_/B sky130_fd_sc_hd__clkdlybuf4s25_1
XFILLER_19_35 VGND VGND VPWR VPWR sky130_fd_sc_hd__decap_3
XFILLER_10_48 VGND VGND VPWR VPWR sky130_fd_sc_hd__decap_3
XFILLER_27_144 VGND VGND VPWR VPWR sky130_fd_sc_hd__fill_1
XFILLER_19_79 VGND VGND VPWR VPWR sky130_fd_sc_hd__fill_2
XFILLER_19_57 VGND VGND VPWR VPWR sky130_fd_sc_hd__decap_3
XFILLER_18_133 VGND VGND VPWR VPWR sky130_fd_sc_hd__decap_3
XFILLER_18_100 VGND VGND VPWR VPWR sky130_fd_sc_hd__decap_3
X_408_ _422_/A _408_/B VGND VGND VPWR VPWR _425_/C sky130_fd_sc_hd__nand2_4
XTAP_TAPCELL_ROW_28_172 VGND VPWR sky130_fd_sc_hd__tapvpwrvgnd_1
XFILLER_18_144 VGND VGND VPWR VPWR sky130_fd_sc_hd__fill_1
X_339_ _339_/A _339_/B VGND VGND VPWR VPWR _550_/B sky130_fd_sc_hd__nand2_2
XFILLER_24_169 VGND VGND VPWR VPWR sky130_fd_sc_hd__decap_3
XFILLER_24_136 VGND VGND VPWR VPWR sky130_fd_sc_hd__decap_3
XFILLER_15_169 VGND VGND VPWR VPWR sky130_fd_sc_hd__decap_3
XFILLER_15_125 VGND VGND VPWR VPWR sky130_fd_sc_hd__decap_3
XFILLER_21_128 VGND VGND VPWR VPWR sky130_fd_sc_hd__decap_3
Xinput30 A[7] VGND VGND VPWR VPWR _628_/B1 sky130_fd_sc_hd__clkdlybuf4s25_1
Xinput41 B[17] VGND VGND VPWR VPWR _396_/B sky130_fd_sc_hd__clkdlybuf4s25_1
Xinput52 B[27] VGND VGND VPWR VPWR _503_/B sky130_fd_sc_hd__clkdlybuf4s25_1
Xinput63 B[8] VGND VGND VPWR VPWR _620_/A2 sky130_fd_sc_hd__clkdlybuf4s25_1
XFILLER_16_58 VGND VGND VPWR VPWR sky130_fd_sc_hd__decap_3
XFILLER_16_25 VGND VGND VPWR VPWR sky130_fd_sc_hd__decap_3
XFILLER_14_3 VGND VGND VPWR VPWR sky130_fd_sc_hd__fill_1
XFILLER_8_70 VGND VGND VPWR VPWR sky130_fd_sc_hd__decap_3
XFILLER_27_57 VGND VGND VPWR VPWR sky130_fd_sc_hd__decap_3
X_587_ _587_/A VGND VGND VPWR VPWR _587_/Y sky130_fd_sc_hd__inv_2
X_656_ _655_/Y _647_/Y _649_/Y VGND VGND VPWR VPWR _657_/D sky130_fd_sc_hd__a21oi_4
X_441_ _441_/A _441_/B VGND VGND VPWR VPWR _441_/X sky130_fd_sc_hd__xor2_2
X_510_ _504_/A _504_/B _509_/X VGND VGND VPWR VPWR _510_/Y sky130_fd_sc_hd__a21oi_2
X_372_ _372_/A _372_/B VGND VGND VPWR VPWR _576_/A sky130_fd_sc_hd__nand2_2
XFILLER_0_193 VGND VGND VPWR VPWR sky130_fd_sc_hd__decap_3
X_639_ _638_/B _638_/A _639_/B1 VGND VGND VPWR VPWR _639_/Y sky130_fd_sc_hd__o21ai_4
XFILLER_24_58 VGND VGND VPWR VPWR sky130_fd_sc_hd__decap_3
X_424_ _422_/A _475_/C _422_/C _416_/Y VGND VGND VPWR VPWR _424_/Y sky130_fd_sc_hd__a31oi_2
X_355_ _363_/A _356_/B VGND VGND VPWR VPWR _355_/Y sky130_fd_sc_hd__nor2_2
XFILLER_14_91 VGND VGND VPWR VPWR sky130_fd_sc_hd__decap_3
Xinput6 A[14] VGND VGND VPWR VPWR _370_/B sky130_fd_sc_hd__clkdlybuf4s25_1
XFILLER_19_47 VGND VGND VPWR VPWR sky130_fd_sc_hd__decap_3
XFILLER_19_25 VGND VGND VPWR VPWR sky130_fd_sc_hd__fill_1
XPHY_EDGE_ROW_14_Right_14 VGND VGND VPWR VPWR sky130_fd_sc_hd__decap_3
XPHY_EDGE_ROW_23_Right_23 VGND VGND VPWR VPWR sky130_fd_sc_hd__decap_3
XFILLER_2_200 VGND VGND VPWR VPWR sky130_fd_sc_hd__fill_2
X_407_ _403_/Y _404_/X _406_/C VGND VGND VPWR VPWR _408_/B sky130_fd_sc_hd__o21bai_4
X_338_ _334_/X _332_/Y _584_/Y VGND VGND VPWR VPWR _339_/B sky130_fd_sc_hd__o21ai_4
XPHY_EDGE_ROW_32_Right_32 VGND VGND VPWR VPWR sky130_fd_sc_hd__decap_3
XTAP_TAPCELL_ROW_19_140 VGND VPWR sky130_fd_sc_hd__tapvpwrvgnd_1
XFILLER_24_115 VGND VGND VPWR VPWR sky130_fd_sc_hd__decap_3
XFILLER_24_104 VGND VGND VPWR VPWR sky130_fd_sc_hd__decap_3
XFILLER_15_137 VGND VGND VPWR VPWR sky130_fd_sc_hd__decap_3
Xinput20 A[27] VGND VGND VPWR VPWR _504_/A sky130_fd_sc_hd__clkdlybuf4s25_1
Xinput31 A[8] VGND VGND VPWR VPWR _620_/B1 sky130_fd_sc_hd__clkdlybuf4s25_1
Xinput42 B[18] VGND VGND VPWR VPWR _405_/B sky130_fd_sc_hd__clkdlybuf4s25_1
Xinput53 B[28] VGND VGND VPWR VPWR _516_/B sky130_fd_sc_hd__clkdlybuf4s25_1
Xinput64 B[9] VGND VGND VPWR VPWR _608_/A sky130_fd_sc_hd__clkdlybuf4s25_1
XPHY_EDGE_ROW_4_Right_4 VGND VGND VPWR VPWR sky130_fd_sc_hd__decap_3
XFILLER_27_25 VGND VGND VPWR VPWR sky130_fd_sc_hd__decap_3
X_586_ _586_/A VGND VGND VPWR VPWR _586_/Y sky130_fd_sc_hd__inv_2
X_655_ _625_/A _655_/A2 _655_/B1 VGND VGND VPWR VPWR _655_/Y sky130_fd_sc_hd__a21oi_2
XFILLER_17_80 VGND VGND VPWR VPWR sky130_fd_sc_hd__decap_3
X_440_ _452_/B _433_/A _452_/A VGND VGND VPWR VPWR _441_/B sky130_fd_sc_hd__a21boi_2
X_371_ _367_/X _369_/Y _370_/B VGND VGND VPWR VPWR _372_/B sky130_fd_sc_hd__o21bai_2
XFILLER_0_172 VGND VGND VPWR VPWR sky130_fd_sc_hd__fill_2
X_569_ _569_/A1 _617_/X _566_/X _605_/Y VGND VGND VPWR VPWR _570_/B sky130_fd_sc_hd__o31a_2
X_638_ _638_/A _638_/B VGND VGND VPWR VPWR _638_/X sky130_fd_sc_hd__and2_2
X_423_ _425_/D _423_/B VGND VGND VPWR VPWR _423_/Y sky130_fd_sc_hd__xnor2_2
X_354_ _363_/A _356_/B VGND VGND VPWR VPWR _359_/C sky130_fd_sc_hd__nand2_2
Xinput7 A[15] VGND VGND VPWR VPWR _375_/B sky130_fd_sc_hd__clkdlybuf4s25_1
XFILLER_4_3 VGND VGND VPWR VPWR sky130_fd_sc_hd__fill_2
XFILLER_18_124 VGND VGND VPWR VPWR sky130_fd_sc_hd__decap_3
X_406_ _403_/Y _406_/B _406_/C VGND VGND VPWR VPWR _422_/A sky130_fd_sc_hd__nand3b_2
X_337_ _332_/Y _337_/B _584_/A VGND VGND VPWR VPWR _339_/A sky130_fd_sc_hd__nand3b_2
XFILLER_25_91 VGND VGND VPWR VPWR sky130_fd_sc_hd__decap_3
XFILLER_24_127 VGND VGND VPWR VPWR sky130_fd_sc_hd__decap_3
XFILLER_32_171 VGND VGND VPWR VPWR sky130_fd_sc_hd__fill_2
XFILLER_21_27 VGND VGND VPWR VPWR sky130_fd_sc_hd__decap_3
XFILLER_15_116 VGND VGND VPWR VPWR sky130_fd_sc_hd__decap_3
XFILLER_15_105 VGND VGND VPWR VPWR sky130_fd_sc_hd__decap_3
XFILLER_30_119 VGND VGND VPWR VPWR sky130_fd_sc_hd__decap_3
XFILLER_11_60 VGND VGND VPWR VPWR sky130_fd_sc_hd__decap_3
Xclone136 _631_/B VGND VGND VPWR VPWR _597_/A sky130_fd_sc_hd__buf_8
XFILLER_21_108 VGND VGND VPWR VPWR sky130_fd_sc_hd__decap_3
Xinput10 A[18] VGND VGND VPWR VPWR _406_/C sky130_fd_sc_hd__clkdlybuf4s25_1
Xinput21 A[28] VGND VGND VPWR VPWR _588_/A sky130_fd_sc_hd__clkdlybuf4s25_1
Xinput32 A[9] VGND VGND VPWR VPWR _617_/A1 sky130_fd_sc_hd__clkdlybuf4s25_1
Xinput43 B[19] VGND VGND VPWR VPWR _414_/B sky130_fd_sc_hd__clkdlybuf4s25_1
Xinput54 B[29] VGND VGND VPWR VPWR _521_/B sky130_fd_sc_hd__clkdlybuf4s25_1
XFILLER_21_119 VGND VGND VPWR VPWR sky130_fd_sc_hd__decap_3
Xinput65 sub VGND VGND VPWR VPWR input65/X sky130_fd_sc_hd__buf_8
XFILLER_20_141 VGND VGND VPWR VPWR sky130_fd_sc_hd__decap_3
XFILLER_20_130 VGND VGND VPWR VPWR sky130_fd_sc_hd__decap_3
XFILLER_12_119 VGND VGND VPWR VPWR sky130_fd_sc_hd__decap_3
XPHY_EDGE_ROW_14_Left_48 VGND VGND VPWR VPWR sky130_fd_sc_hd__decap_3
XFILLER_8_94 VGND VGND VPWR VPWR sky130_fd_sc_hd__decap_3
XFILLER_8_50 VGND VGND VPWR VPWR sky130_fd_sc_hd__decap_3
XFILLER_27_37 VGND VGND VPWR VPWR sky130_fd_sc_hd__fill_2
XFILLER_27_15 VGND VGND VPWR VPWR sky130_fd_sc_hd__fill_2
XTAP_TAPCELL_ROW_10_106 VGND VPWR sky130_fd_sc_hd__tapvpwrvgnd_1
X_654_ _628_/Y _625_/Y _627_/Y VGND VGND VPWR VPWR _657_/C sky130_fd_sc_hd__a21oi_4
X_585_ _585_/A VGND VGND VPWR VPWR _585_/Y sky130_fd_sc_hd__inv_2
XFILLER_17_92 VGND VGND VPWR VPWR sky130_fd_sc_hd__decap_3
XFILLER_17_70 VGND VGND VPWR VPWR sky130_fd_sc_hd__fill_2
XFILLER_3_192 VGND VGND VPWR VPWR sky130_fd_sc_hd__fill_1
X_370_ _369_/Y _370_/B _370_/C VGND VGND VPWR VPWR _372_/A sky130_fd_sc_hd__nand3b_2
X_637_ _638_/A _638_/B VGND VGND VPWR VPWR _645_/C sky130_fd_sc_hd__nand2b_4
XFILLER_28_80 VGND VGND VPWR VPWR sky130_fd_sc_hd__decap_3
X_499_ _499_/A _499_/B VGND VGND VPWR VPWR _499_/Y sky130_fd_sc_hd__nand2_2
X_568_ _568_/A _568_/B VGND VGND VPWR VPWR _568_/Y sky130_fd_sc_hd__xnor2_2
XFILLER_24_49 VGND VGND VPWR VPWR sky130_fd_sc_hd__decap_3
XFILLER_24_27 VGND VGND VPWR VPWR sky130_fd_sc_hd__fill_1
XPHY_EDGE_ROW_17_Left_51 VGND VGND VPWR VPWR sky130_fd_sc_hd__decap_3
X_422_ _422_/A _422_/B _422_/C VGND VGND VPWR VPWR _423_/B sky130_fd_sc_hd__nand3_2
X_353_ _363_/A _356_/B VGND VGND VPWR VPWR _353_/X sky130_fd_sc_hd__and2_4
Xinput8 A[16] VGND VGND VPWR VPWR _390_/B sky130_fd_sc_hd__clkdlybuf4s25_1
XFILLER_10_29 VGND VGND VPWR VPWR sky130_fd_sc_hd__decap_3
XFILLER_19_38 VGND VGND VPWR VPWR sky130_fd_sc_hd__decap_3
XPHY_EDGE_ROW_2_Left_36 VGND VGND VPWR VPWR sky130_fd_sc_hd__decap_3
XFILLER_18_136 VGND VGND VPWR VPWR sky130_fd_sc_hd__decap_3
X_405_ _503_/A _405_/B VGND VGND VPWR VPWR _406_/B sky130_fd_sc_hd__nand2_2
X_336_ _336_/A _337_/B VGND VGND VPWR VPWR _336_/Y sky130_fd_sc_hd__nand2_4
XFILLER_2_85 VGND VGND VPWR VPWR sky130_fd_sc_hd__fill_2
XFILLER_24_139 VGND VGND VPWR VPWR sky130_fd_sc_hd__fill_1
XFILLER_32_194 VGND VGND VPWR VPWR sky130_fd_sc_hd__fill_2
XFILLER_15_128 VGND VGND VPWR VPWR sky130_fd_sc_hd__decap_3
XFILLER_11_72 VGND VGND VPWR VPWR sky130_fd_sc_hd__decap_3
Xinput11 A[19] VGND VGND VPWR VPWR _415_/C sky130_fd_sc_hd__clkdlybuf4s25_1
Xinput22 A[29] VGND VGND VPWR VPWR _589_/A sky130_fd_sc_hd__clkdlybuf4s25_1
Xinput33 B[0] VGND VGND VPWR VPWR _547_/S sky130_fd_sc_hd__clkdlybuf4s25_1
Xinput44 B[1] VGND VGND VPWR VPWR _314_/B sky130_fd_sc_hd__clkdlybuf4s25_1
Xinput55 B[2] VGND VGND VPWR VPWR _335_/B sky130_fd_sc_hd__clkdlybuf4s25_1
X_319_ _319_/A _547_/S VGND VGND VPWR VPWR _319_/X sky130_fd_sc_hd__and2_4
XTAP_TAPCELL_ROW_22_148 VGND VPWR sky130_fd_sc_hd__tapvpwrvgnd_1
XFILLER_20_153 VGND VGND VPWR VPWR sky130_fd_sc_hd__decap_3
XFILLER_11_142 VGND VGND VPWR VPWR sky130_fd_sc_hd__decap_3
XFILLER_8_73 VGND VGND VPWR VPWR sky130_fd_sc_hd__decap_3
XFILLER_27_49 VGND VGND VPWR VPWR sky130_fd_sc_hd__decap_3
XTAP_TAPCELL_ROW_10_107 VGND VPWR sky130_fd_sc_hd__tapvpwrvgnd_1
XPHY_EDGE_ROW_31_Left_65 VGND VGND VPWR VPWR sky130_fd_sc_hd__decap_3
X_653_ _651_/Y _650_/Y _629_/X VGND VGND VPWR VPWR _653_/Y sky130_fd_sc_hd__a21oi_4
X_584_ _584_/A VGND VGND VPWR VPWR _584_/Y sky130_fd_sc_hd__inv_2
XFILLER_17_60 VGND VGND VPWR VPWR sky130_fd_sc_hd__decap_3
XTAP_TAPCELL_ROW_4_85 VGND VPWR sky130_fd_sc_hd__tapvpwrvgnd_1
XFILLER_12_3 VGND VGND VPWR VPWR sky130_fd_sc_hd__fill_1
X_567_ _623_/D _563_/C _617_/X VGND VGND VPWR VPWR _568_/B sky130_fd_sc_hd__a21oi_4
X_636_ _638_/B _638_/A VGND VGND VPWR VPWR _645_/B sky130_fd_sc_hd__nand2b_2
X_498_ _498_/A _500_/C VGND VGND VPWR VPWR _499_/B sky130_fd_sc_hd__nand2_2
XFILLER_5_74 VGND VGND VPWR VPWR sky130_fd_sc_hd__fill_1
X_421_ _585_/A _397_/Y _408_/B _410_/Y VGND VGND VPWR VPWR _422_/C sky130_fd_sc_hd__o211ai_2
X_352_ _350_/Y _349_/Y _352_/B1 _652_/X VGND VGND VPWR VPWR _352_/Y sky130_fd_sc_hd__o2bb2ai_4
XFILLER_14_94 VGND VGND VPWR VPWR sky130_fd_sc_hd__decap_3
XTAP_TAPCELL_ROW_1_75 VGND VPWR sky130_fd_sc_hd__tapvpwrvgnd_1
XFILLER_30_71 VGND VGND VPWR VPWR sky130_fd_sc_hd__decap_3
Xinput9 A[17] VGND VGND VPWR VPWR _585_/A sky130_fd_sc_hd__clkdlybuf4s25_1
X_619_ _617_/X _607_/X _618_/X VGND VGND VPWR VPWR _619_/Y sky130_fd_sc_hd__a21oi_4
X_404_ _503_/A _405_/B VGND VGND VPWR VPWR _404_/X sky130_fd_sc_hd__and2_2
XFILLER_26_170 VGND VGND VPWR VPWR sky130_fd_sc_hd__fill_2
X_335_ _335_/A _335_/B VGND VGND VPWR VPWR _337_/B sky130_fd_sc_hd__nand2_2
XFILLER_25_82 VGND VGND VPWR VPWR sky130_fd_sc_hd__decap_3
XPHY_EDGE_ROW_10_Right_10 VGND VGND VPWR VPWR sky130_fd_sc_hd__decap_3
XFILLER_2_64 VGND VGND VPWR VPWR sky130_fd_sc_hd__fill_2
XFILLER_24_107 VGND VGND VPWR VPWR sky130_fd_sc_hd__decap_3
XFILLER_24_118 VGND VGND VPWR VPWR sky130_fd_sc_hd__decap_3
XTAP_TAPCELL_ROW_33_190 VGND VPWR sky130_fd_sc_hd__tapvpwrvgnd_1
XFILLER_23_195 VGND VGND VPWR VPWR sky130_fd_sc_hd__decap_3
XFILLER_23_151 VGND VGND VPWR VPWR sky130_fd_sc_hd__decap_3
XFILLER_11_51 VGND VGND VPWR VPWR sky130_fd_sc_hd__decap_3
XTAP_TAPCELL_ROW_7_96 VGND VPWR sky130_fd_sc_hd__tapvpwrvgnd_1
XFILLER_14_173 VGND VGND VPWR VPWR sky130_fd_sc_hd__fill_1
Xinput12 A[1] VGND VGND VPWR VPWR _316_/B1 sky130_fd_sc_hd__clkdlybuf4s25_1
Xinput23 A[2] VGND VGND VPWR VPWR _584_/A sky130_fd_sc_hd__clkdlybuf4s25_1
Xinput34 B[10] VGND VGND VPWR VPWR _598_/B sky130_fd_sc_hd__dlymetal6s4s_1
Xinput45 B[20] VGND VGND VPWR VPWR _429_/B sky130_fd_sc_hd__clkdlybuf4s25_1
Xinput56 B[30] VGND VGND VPWR VPWR _529_/B sky130_fd_sc_hd__clkdlybuf4s25_1
X_318_ _318_/A _341_/D VGND VGND VPWR VPWR _548_/B sky130_fd_sc_hd__nand2_4
XFILLER_16_29 VGND VGND VPWR VPWR sky130_fd_sc_hd__decap_3
XTAP_TAPCELL_ROW_22_149 VGND VPWR sky130_fd_sc_hd__tapvpwrvgnd_1
XFILLER_20_121 VGND VGND VPWR VPWR sky130_fd_sc_hd__decap_3
XFILLER_22_50 VGND VGND VPWR VPWR sky130_fd_sc_hd__fill_1
XFILLER_8_85 VGND VGND VPWR VPWR sky130_fd_sc_hd__decap_3
XFILLER_8_41 VGND VGND VPWR VPWR sky130_fd_sc_hd__decap_3
XFILLER_6_191 VGND VGND VPWR VPWR sky130_fd_sc_hd__decap_3
XFILLER_27_28 VGND VGND VPWR VPWR sky130_fd_sc_hd__decap_3
XTAP_TAPCELL_ROW_10_108 VGND VPWR sky130_fd_sc_hd__tapvpwrvgnd_1
X_583_ _583_/A VGND VGND VPWR VPWR _583_/Y sky130_fd_sc_hd__inv_2
X_652_ _651_/Y _650_/Y _629_/X VGND VGND VPWR VPWR _652_/X sky130_fd_sc_hd__a21o_2
XFILLER_17_83 VGND VGND VPWR VPWR sky130_fd_sc_hd__decap_3
XTAP_TAPCELL_ROW_4_86 VGND VPWR sky130_fd_sc_hd__tapvpwrvgnd_1
XPHY_EDGE_ROW_8_Right_8 VGND VGND VPWR VPWR sky130_fd_sc_hd__decap_3
XFILLER_13_19 VGND VGND VPWR VPWR sky130_fd_sc_hd__decap_3
XFILLER_0_197 VGND VGND VPWR VPWR sky130_fd_sc_hd__decap_3
X_566_ _653_/Y _561_/C _561_/A _623_/D VGND VGND VPWR VPWR _566_/X sky130_fd_sc_hd__o211a_2
X_635_ _638_/A _632_/B _634_/Y VGND VGND VPWR VPWR _635_/Y sky130_fd_sc_hd__a21oi_2
X_497_ _486_/Y _497_/A2 _486_/C _487_/Y _508_/B VGND VGND VPWR VPWR _499_/A sky130_fd_sc_hd__o2111ai_2
XFILLER_24_29 VGND VGND VPWR VPWR sky130_fd_sc_hd__decap_3
X_420_ _420_/A _475_/D VGND VGND VPWR VPWR _422_/B sky130_fd_sc_hd__nand2_2
X_351_ _653_/Y _624_/Y _349_/Y _350_/Y VGND VGND VPWR VPWR _571_/B sky130_fd_sc_hd__a22oi_4
XFILLER_5_201 VGND VGND VPWR VPWR sky130_fd_sc_hd__fill_1
XTAP_TAPCELL_ROW_1_76 VGND VPWR sky130_fd_sc_hd__tapvpwrvgnd_1
X_549_ _324_/C _549_/A2 _324_/Y VGND VGND VPWR VPWR _550_/A sky130_fd_sc_hd__a21boi_4
X_618_ _591_/X _594_/Y _595_/Y _602_/Y VGND VGND VPWR VPWR _618_/X sky130_fd_sc_hd__a2bb2o_4
XFILLER_27_105 VGND VGND VPWR VPWR sky130_fd_sc_hd__fill_2
XFILLER_18_127 VGND VGND VPWR VPWR sky130_fd_sc_hd__decap_3
X_403_ _503_/A _405_/B VGND VGND VPWR VPWR _403_/Y sky130_fd_sc_hd__nor2_2
X_334_ _335_/A _335_/B VGND VGND VPWR VPWR _334_/X sky130_fd_sc_hd__and2_4
XFILLER_25_94 VGND VGND VPWR VPWR sky130_fd_sc_hd__decap_3
Xrebuffer180 _555_/B VGND VGND VPWR VPWR _558_/A4 sky130_fd_sc_hd__buf_6
XFILLER_32_141 VGND VGND VPWR VPWR sky130_fd_sc_hd__decap_3
XFILLER_32_130 VGND VGND VPWR VPWR sky130_fd_sc_hd__decap_3
XFILLER_21_19 VGND VGND VPWR VPWR sky130_fd_sc_hd__fill_1
XFILLER_15_119 VGND VGND VPWR VPWR sky130_fd_sc_hd__decap_3
XFILLER_15_108 VGND VGND VPWR VPWR sky130_fd_sc_hd__decap_3
XTAP_TAPCELL_ROW_33_191 VGND VPWR sky130_fd_sc_hd__tapvpwrvgnd_1
XFILLER_2_3 VGND VGND VPWR VPWR sky130_fd_sc_hd__decap_3
XFILLER_11_63 VGND VGND VPWR VPWR sky130_fd_sc_hd__decap_3
Xinput13 A[20] VGND VGND VPWR VPWR _430_/B sky130_fd_sc_hd__clkdlybuf4s25_1
X_317_ _317_/A _317_/B VGND VGND VPWR VPWR _341_/D sky130_fd_sc_hd__nand2_4
XTAP_TAPCELL_ROW_7_97 VGND VPWR sky130_fd_sc_hd__tapvpwrvgnd_1
XFILLER_14_141 VGND VGND VPWR VPWR sky130_fd_sc_hd__fill_2
Xinput24 A[30] VGND VGND VPWR VPWR _532_/A sky130_fd_sc_hd__clkdlybuf4s25_1
Xinput35 B[11] VGND VGND VPWR VPWR _593_/B sky130_fd_sc_hd__clkdlybuf4s25_1
Xinput46 B[21] VGND VGND VPWR VPWR _435_/B sky130_fd_sc_hd__clkdlybuf4s25_1
Xinput57 B[31] VGND VGND VPWR VPWR _539_/B sky130_fd_sc_hd__clkdlybuf4s25_1
XFILLER_32_29 VGND VGND VPWR VPWR sky130_fd_sc_hd__fill_2
XFILLER_20_144 VGND VGND VPWR VPWR sky130_fd_sc_hd__decap_3
XFILLER_20_133 VGND VGND VPWR VPWR sky130_fd_sc_hd__decap_3
XFILLER_20_111 VGND VGND VPWR VPWR sky130_fd_sc_hd__fill_1
XFILLER_20_100 VGND VGND VPWR VPWR sky130_fd_sc_hd__decap_3
XFILLER_28_200 VGND VGND VPWR VPWR sky130_fd_sc_hd__fill_2
XTAP_TAPCELL_ROW_13_117 VGND VPWR sky130_fd_sc_hd__tapvpwrvgnd_1
XFILLER_11_133 VGND VGND VPWR VPWR sky130_fd_sc_hd__decap_3
XFILLER_8_97 VGND VGND VPWR VPWR sky130_fd_sc_hd__fill_1
XFILLER_8_53 VGND VGND VPWR VPWR sky130_fd_sc_hd__decap_3
XTAP_TAPCELL_ROW_10_109 VGND VPWR sky130_fd_sc_hd__tapvpwrvgnd_1
X_582_ _625_/B VGND VGND VPWR VPWR _582_/Y sky130_fd_sc_hd__inv_2
X_651_ _651_/A1 _640_/Y _635_/Y _627_/Y VGND VGND VPWR VPWR _651_/Y sky130_fd_sc_hd__a211oi_4
XFILLER_17_95 VGND VGND VPWR VPWR sky130_fd_sc_hd__decap_3
XTAP_TAPCELL_ROW_4_87 VGND VPWR sky130_fd_sc_hd__tapvpwrvgnd_1
XFILLER_33_72 VGND VGND VPWR VPWR sky130_fd_sc_hd__decap_3
X_634_ _631_/B _632_/B _634_/B1 VGND VGND VPWR VPWR _634_/Y sky130_fd_sc_hd__o21ai_2
XFILLER_28_83 VGND VGND VPWR VPWR sky130_fd_sc_hd__fill_1
XFILLER_0_165 VGND VGND VPWR VPWR sky130_fd_sc_hd__decap_3
X_496_ _496_/A _496_/B VGND VGND VPWR VPWR _500_/C sky130_fd_sc_hd__nand2_2
X_565_ _565_/A _565_/B VGND VGND VPWR VPWR _565_/Y sky130_fd_sc_hd__nor2_2
X_350_ _350_/A _350_/B _619_/Y VGND VGND VPWR VPWR _350_/Y sky130_fd_sc_hd__nand3_4
XFILLER_14_85 VGND VGND VPWR VPWR sky130_fd_sc_hd__decap_3
XTAP_TAPCELL_ROW_1_77 VGND VPWR sky130_fd_sc_hd__tapvpwrvgnd_1
XFILLER_30_95 VGND VGND VPWR VPWR sky130_fd_sc_hd__decap_3
X_617_ _617_/A1 _608_/Y _610_/Y _613_/Y _616_/Y VGND VGND VPWR VPWR _617_/X sky130_fd_sc_hd__o32a_4
X_479_ _490_/A _480_/B VGND VGND VPWR VPWR _481_/A sky130_fd_sc_hd__nor2_2
X_548_ _548_/A _548_/B VGND VGND VPWR VPWR _548_/Y sky130_fd_sc_hd__xnor2_2
XFILLER_27_128 VGND VGND VPWR VPWR sky130_fd_sc_hd__fill_2
XFILLER_18_139 VGND VGND VPWR VPWR sky130_fd_sc_hd__fill_1
X_402_ _425_/B _402_/B VGND VGND VPWR VPWR _402_/Y sky130_fd_sc_hd__xnor2_2
X_333_ _335_/A _335_/B VGND VGND VPWR VPWR _336_/A sky130_fd_sc_hd__or2_4
XFILLER_25_73 VGND VGND VPWR VPWR sky130_fd_sc_hd__decap_3
XFILLER_32_120 VGND VGND VPWR VPWR sky130_fd_sc_hd__fill_1
XFILLER_32_197 VGND VGND VPWR VPWR sky130_fd_sc_hd__decap_3
XTAP_TAPCELL_ROW_25_159 VGND VPWR sky130_fd_sc_hd__tapvpwrvgnd_1
XTAP_TAPCELL_ROW_33_192 VGND VPWR sky130_fd_sc_hd__tapvpwrvgnd_1
Xinput14 A[21] VGND VGND VPWR VPWR input14/X sky130_fd_sc_hd__clkdlybuf4s25_1
Xinput25 A[31] VGND VGND VPWR VPWR _590_/A sky130_fd_sc_hd__clkdlybuf4s25_1
Xinput36 B[12] VGND VGND VPWR VPWR _363_/B sky130_fd_sc_hd__clkdlybuf4s25_1
X_316_ _314_/B _319_/A _316_/B1 VGND VGND VPWR VPWR _316_/X sky130_fd_sc_hd__o21a_4
XTAP_TAPCELL_ROW_7_98 VGND VPWR sky130_fd_sc_hd__tapvpwrvgnd_1
Xinput47 B[22] VGND VGND VPWR VPWR _445_/B sky130_fd_sc_hd__clkdlybuf4s25_1
Xinput58 B[3] VGND VGND VPWR VPWR _327_/B sky130_fd_sc_hd__clkdlybuf4s25_1
XFILLER_20_156 VGND VGND VPWR VPWR sky130_fd_sc_hd__decap_3
XTAP_TAPCELL_ROW_13_118 VGND VPWR sky130_fd_sc_hd__tapvpwrvgnd_1
XFILLER_22_41 VGND VGND VPWR VPWR sky130_fd_sc_hd__decap_3
XFILLER_11_145 VGND VGND VPWR VPWR sky130_fd_sc_hd__decap_3
XFILLER_22_85 VGND VGND VPWR VPWR sky130_fd_sc_hd__decap_3
XFILLER_19_201 VGND VGND VPWR VPWR sky130_fd_sc_hd__fill_1
XFILLER_8_76 VGND VGND VPWR VPWR sky130_fd_sc_hd__fill_1
X_650_ _638_/X _639_/Y _645_/Y _649_/Y _657_/B VGND VGND VPWR VPWR _650_/Y sky130_fd_sc_hd__o2111ai_4
X_581_ _581_/A VGND VGND VPWR VPWR _595_/A sky130_fd_sc_hd__inv_2
XPHY_EDGE_ROW_9_Left_43 VGND VGND VPWR VPWR sky130_fd_sc_hd__decap_3
XFILLER_17_63 VGND VGND VPWR VPWR sky130_fd_sc_hd__fill_1
XTAP_TAPCELL_ROW_4_88 VGND VPWR sky130_fd_sc_hd__tapvpwrvgnd_1
XFILLER_3_163 VGND VGND VPWR VPWR sky130_fd_sc_hd__decap_3
XFILLER_0_111 VGND VGND VPWR VPWR sky130_fd_sc_hd__fill_1
X_633_ _634_/B1 _633_/B _633_/C VGND VGND VPWR VPWR _633_/Y sky130_fd_sc_hd__nand3b_4
X_495_ _495_/A _495_/B VGND VGND VPWR VPWR _508_/B sky130_fd_sc_hd__xnor2_2
X_564_ _616_/Y _563_/C _623_/D VGND VGND VPWR VPWR _565_/B sky130_fd_sc_hd__o21a_2
XFILLER_10_3 VGND VGND VPWR VPWR sky130_fd_sc_hd__decap_3
XFILLER_30_74 VGND VGND VPWR VPWR sky130_fd_sc_hd__fill_2
XFILLER_14_97 VGND VGND VPWR VPWR sky130_fd_sc_hd__decap_3
X_547_ _428_/A input1/X _547_/S VGND VGND VPWR VPWR _548_/A sky130_fd_sc_hd__mux2_1
X_616_ _616_/A1 _620_/A2 _615_/Y VGND VGND VPWR VPWR _616_/Y sky130_fd_sc_hd__a21oi_4
XFILLER_29_181 VGND VGND VPWR VPWR sky130_fd_sc_hd__fill_2
X_478_ _500_/A _478_/B VGND VGND VPWR VPWR _478_/X sky130_fd_sc_hd__xor2_4
X_401_ _425_/A _385_/Y _409_/A VGND VGND VPWR VPWR _402_/B sky130_fd_sc_hd__o21ai_2
X_332_ _335_/A _335_/B VGND VGND VPWR VPWR _332_/Y sky130_fd_sc_hd__nor2_4
XFILLER_26_184 VGND VGND VPWR VPWR sky130_fd_sc_hd__decap_3
XFILLER_25_85 VGND VGND VPWR VPWR sky130_fd_sc_hd__decap_3
XPHY_EDGE_ROW_22_Left_56 VGND VGND VPWR VPWR sky130_fd_sc_hd__decap_3
XFILLER_2_12 VGND VGND VPWR VPWR sky130_fd_sc_hd__decap_3
XTAP_TAPCELL_ROW_33_193 VGND VPWR sky130_fd_sc_hd__tapvpwrvgnd_1
XFILLER_23_198 VGND VGND VPWR VPWR sky130_fd_sc_hd__decap_3
XFILLER_23_154 VGND VGND VPWR VPWR sky130_fd_sc_hd__fill_1
XFILLER_23_132 VGND VGND VPWR VPWR sky130_fd_sc_hd__fill_2
XFILLER_11_54 VGND VGND VPWR VPWR sky130_fd_sc_hd__fill_2
XTAP_TAPCELL_ROW_16_127 VGND VPWR sky130_fd_sc_hd__tapvpwrvgnd_1
XFILLER_14_121 VGND VGND VPWR VPWR sky130_fd_sc_hd__decap_3
Xinput15 A[22] VGND VGND VPWR VPWR _447_/C sky130_fd_sc_hd__clkdlybuf4s25_1
Xinput26 A[3] VGND VGND VPWR VPWR _583_/A sky130_fd_sc_hd__clkdlybuf4s25_1
Xinput37 B[13] VGND VGND VPWR VPWR _356_/B sky130_fd_sc_hd__clkdlybuf4s25_1
Xinput48 B[23] VGND VGND VPWR VPWR _457_/B sky130_fd_sc_hd__clkdlybuf4s25_1
Xinput59 B[4] VGND VGND VPWR VPWR _655_/A2 sky130_fd_sc_hd__clkdlybuf4s25_1
X_315_ _316_/B1 _315_/B _658_/Y VGND VGND VPWR VPWR _341_/C sky130_fd_sc_hd__nand3b_4
XFILLER_20_124 VGND VGND VPWR VPWR sky130_fd_sc_hd__decap_3
XTAP_TAPCELL_ROW_13_119 VGND VPWR sky130_fd_sc_hd__tapvpwrvgnd_1
XFILLER_11_113 VGND VGND VPWR VPWR sky130_fd_sc_hd__decap_3
XFILLER_8_88 VGND VGND VPWR VPWR sky130_fd_sc_hd__decap_3
XFILLER_8_44 VGND VGND VPWR VPWR sky130_fd_sc_hd__decap_3
XFILLER_6_194 VGND VGND VPWR VPWR sky130_fd_sc_hd__fill_2
XFILLER_6_172 VGND VGND VPWR VPWR sky130_fd_sc_hd__decap_3
X_580_ _580_/A VGND VGND VPWR VPWR _625_/A sky130_fd_sc_hd__inv_2
XFILLER_17_86 VGND VGND VPWR VPWR sky130_fd_sc_hd__decap_3
XFILLER_33_85 VGND VGND VPWR VPWR sky130_fd_sc_hd__decap_3
XPHY_EDGE_ROW_17_Right_17 VGND VGND VPWR VPWR sky130_fd_sc_hd__decap_3
XFILLER_0_123 VGND VGND VPWR VPWR sky130_fd_sc_hd__fill_2
XPHY_EDGE_ROW_26_Right_26 VGND VGND VPWR VPWR sky130_fd_sc_hd__decap_3
X_563_ _616_/Y _623_/D _563_/C VGND VGND VPWR VPWR _565_/A sky130_fd_sc_hd__nor3_2
X_632_ _631_/B _632_/B VGND VGND VPWR VPWR _633_/B sky130_fd_sc_hd__nand2b_4
XFILLER_28_74 VGND VGND VPWR VPWR sky130_fd_sc_hd__fill_2
X_494_ _492_/C _492_/A _495_/A VGND VGND VPWR VPWR _496_/B sky130_fd_sc_hd__a21o_2
XFILLER_8_201 VGND VGND VPWR VPWR sky130_fd_sc_hd__fill_1
X_546_ _546_/A _546_/B VGND VGND VPWR VPWR _546_/Y sky130_fd_sc_hd__nor2_4
X_615_ _647_/B _620_/A2 _620_/B1 VGND VGND VPWR VPWR _615_/Y sky130_fd_sc_hd__o21ai_4
X_477_ _476_/Y _393_/B _474_/Y VGND VGND VPWR VPWR _500_/D sky130_fd_sc_hd__a21boi_4
X_400_ _409_/C _409_/D VGND VGND VPWR VPWR _425_/B sky130_fd_sc_hd__nand2_2
X_331_ _327_/X _329_/Y _330_/Y VGND VGND VPWR VPWR _552_/B sky130_fd_sc_hd__o21a_2
XTAP_TAPCELL_ROW_28_169 VGND VPWR sky130_fd_sc_hd__tapvpwrvgnd_1
XFILLER_26_141 VGND VGND VPWR VPWR sky130_fd_sc_hd__decap_3
XFILLER_26_130 VGND VGND VPWR VPWR sky130_fd_sc_hd__decap_3
Xrebuffer150 _319_/A VGND VGND VPWR VPWR _320_/B sky130_fd_sc_hd__buf_6
XFILLER_25_97 VGND VGND VPWR VPWR sky130_fd_sc_hd__decap_3
X_529_ _529_/A _529_/B VGND VGND VPWR VPWR _531_/B sky130_fd_sc_hd__nand2_2
XFILLER_32_144 VGND VGND VPWR VPWR sky130_fd_sc_hd__fill_2
XFILLER_17_196 VGND VGND VPWR VPWR sky130_fd_sc_hd__decap_3
XFILLER_17_141 VGND VGND VPWR VPWR sky130_fd_sc_hd__fill_2
XFILLER_2_6 VGND VGND VPWR VPWR sky130_fd_sc_hd__decap_3
XFILLER_11_66 VGND VGND VPWR VPWR sky130_fd_sc_hd__decap_3
X_314_ _319_/A _314_/B VGND VGND VPWR VPWR _317_/B sky130_fd_sc_hd__nand2_2
XTAP_TAPCELL_ROW_16_128 VGND VPWR sky130_fd_sc_hd__tapvpwrvgnd_1
XFILLER_14_100 VGND VGND VPWR VPWR sky130_fd_sc_hd__decap_3
Xinput16 A[23] VGND VGND VPWR VPWR _586_/A sky130_fd_sc_hd__clkdlybuf4s25_1
Xinput27 A[4] VGND VGND VPWR VPWR _655_/B1 sky130_fd_sc_hd__clkdlybuf4s25_1
Xinput38 B[14] VGND VGND VPWR VPWR _369_/B sky130_fd_sc_hd__clkdlybuf4s25_1
Xinput49 B[24] VGND VGND VPWR VPWR _467_/B sky130_fd_sc_hd__clkdlybuf4s25_1
XFILLER_20_136 VGND VGND VPWR VPWR sky130_fd_sc_hd__decap_3
XFILLER_22_98 VGND VGND VPWR VPWR sky130_fd_sc_hd__decap_3
XFILLER_11_136 VGND VGND VPWR VPWR sky130_fd_sc_hd__decap_3
XFILLER_0_3 VGND VGND VPWR VPWR sky130_fd_sc_hd__decap_3
XFILLER_8_67 VGND VGND VPWR VPWR sky130_fd_sc_hd__decap_3
XFILLER_8_56 VGND VGND VPWR VPWR sky130_fd_sc_hd__fill_2
XFILLER_33_20 VGND VGND VPWR VPWR sky130_fd_sc_hd__decap_3
XFILLER_17_98 VGND VGND VPWR VPWR sky130_fd_sc_hd__decap_3
XFILLER_0_113 VGND VGND VPWR VPWR sky130_fd_sc_hd__fill_2
X_493_ _492_/C _492_/A _495_/A VGND VGND VPWR VPWR _493_/Y sky130_fd_sc_hd__a21oi_2
X_562_ _563_/C _562_/B VGND VGND VPWR VPWR _562_/Y sky130_fd_sc_hd__nor2_2
X_631_ _632_/B _631_/B VGND VGND VPWR VPWR _633_/C sky130_fd_sc_hd__nand2b_2
XFILLER_14_88 VGND VGND VPWR VPWR sky130_fd_sc_hd__decap_3
XFILLER_30_98 VGND VGND VPWR VPWR sky130_fd_sc_hd__decap_3
XFILLER_30_54 VGND VGND VPWR VPWR sky130_fd_sc_hd__decap_3
XFILLER_30_32 VGND VGND VPWR VPWR sky130_fd_sc_hd__fill_1
XFILLER_30_21 VGND VGND VPWR VPWR sky130_fd_sc_hd__decap_3
XFILLER_29_172 VGND VGND VPWR VPWR sky130_fd_sc_hd__decap_3
X_476_ _513_/A VGND VGND VPWR VPWR _476_/Y sky130_fd_sc_hd__inv_2
X_545_ _321_/Y _545_/A2 _335_/A VGND VGND VPWR VPWR _546_/A sky130_fd_sc_hd__a21oi_2
X_614_ _620_/A2 _614_/B VGND VGND VPWR VPWR _614_/Y sky130_fd_sc_hd__nand2b_2
X_330_ _583_/Y _330_/B _330_/C VGND VGND VPWR VPWR _330_/Y sky130_fd_sc_hd__nand3_2
XFILLER_26_197 VGND VGND VPWR VPWR sky130_fd_sc_hd__decap_3
XFILLER_26_164 VGND VGND VPWR VPWR sky130_fd_sc_hd__decap_3
XFILLER_25_76 VGND VGND VPWR VPWR sky130_fd_sc_hd__fill_2
Xrebuffer151 _511_/Y VGND VGND VPWR VPWR _514_/B1 sky130_fd_sc_hd__buf_2
Xrebuffer140 _380_/B VGND VGND VPWR VPWR _572_/A sky130_fd_sc_hd__buf_2
XFILLER_17_164 VGND VGND VPWR VPWR sky130_fd_sc_hd__decap_3
XFILLER_17_120 VGND VGND VPWR VPWR sky130_fd_sc_hd__decap_3
X_459_ _586_/Y _460_/B _460_/C VGND VGND VPWR VPWR _459_/X sky130_fd_sc_hd__and3_2
X_528_ _529_/A _529_/B VGND VGND VPWR VPWR _531_/A sky130_fd_sc_hd__or2_2
XFILLER_23_123 VGND VGND VPWR VPWR sky130_fd_sc_hd__decap_3
XFILLER_11_45 VGND VGND VPWR VPWR sky130_fd_sc_hd__decap_3
X_313_ _319_/A _314_/B VGND VGND VPWR VPWR _315_/B sky130_fd_sc_hd__nand2b_4
XTAP_TAPCELL_ROW_16_129 VGND VPWR sky130_fd_sc_hd__tapvpwrvgnd_1
XFILLER_14_156 VGND VGND VPWR VPWR sky130_fd_sc_hd__decap_3
XFILLER_14_112 VGND VGND VPWR VPWR sky130_fd_sc_hd__decap_3
Xinput17 A[24] VGND VGND VPWR VPWR _587_/A sky130_fd_sc_hd__clkdlybuf4s25_1
Xinput28 A[5] VGND VGND VPWR VPWR _639_/B1 sky130_fd_sc_hd__clkdlybuf4s25_1
Xinput39 B[15] VGND VGND VPWR VPWR _374_/A sky130_fd_sc_hd__clkdlybuf4s25_1
XTAP_TAPCELL_ROW_30_176 VGND VPWR sky130_fd_sc_hd__tapvpwrvgnd_1
XFILLER_20_115 VGND VGND VPWR VPWR sky130_fd_sc_hd__decap_3
XFILLER_7_119 VGND VGND VPWR VPWR sky130_fd_sc_hd__fill_1
XFILLER_22_88 VGND VGND VPWR VPWR sky130_fd_sc_hd__fill_1
XFILLER_22_44 VGND VGND VPWR VPWR sky130_fd_sc_hd__decap_3
XFILLER_17_77 VGND VGND VPWR VPWR sky130_fd_sc_hd__decap_3
XFILLER_17_33 VGND VGND VPWR VPWR sky130_fd_sc_hd__decap_3
XFILLER_3_166 VGND VGND VPWR VPWR sky130_fd_sc_hd__fill_2
XFILLER_12_9 VGND VGND VPWR VPWR sky130_fd_sc_hd__fill_1
XPHY_EDGE_ROW_3_Right_3 VGND VGND VPWR VPWR sky130_fd_sc_hd__decap_3
X_630_ _638_/A _632_/B VGND VGND VPWR VPWR _630_/X sky130_fd_sc_hd__and2_2
XFILLER_0_169 VGND VGND VPWR VPWR sky130_fd_sc_hd__decap_3
X_492_ _492_/A _495_/A _492_/C VGND VGND VPWR VPWR _496_/A sky130_fd_sc_hd__nand3_2
X_561_ _561_/A _561_/B _561_/C VGND VGND VPWR VPWR _562_/B sky130_fd_sc_hd__nor3_2
XFILLER_28_98 VGND VGND VPWR VPWR sky130_fd_sc_hd__decap_3
XTAP_TAPCELL_ROW_5_90 VGND VPWR sky130_fd_sc_hd__tapvpwrvgnd_1
X_613_ _616_/A1 _608_/A _612_/Y VGND VGND VPWR VPWR _613_/Y sky130_fd_sc_hd__a21oi_2
XFILLER_29_140 VGND VGND VPWR VPWR sky130_fd_sc_hd__decap_3
X_475_ _475_/A _475_/B _475_/C _475_/D VGND VGND VPWR VPWR _513_/A sky130_fd_sc_hd__nand4_4
X_544_ _537_/Y _536_/B _540_/Y _541_/X _543_/Y VGND VGND VPWR VPWR _544_/Y sky130_fd_sc_hd__a41oi_4
XFILLER_26_121 VGND VGND VPWR VPWR sky130_fd_sc_hd__decap_3
XFILLER_25_88 VGND VGND VPWR VPWR sky130_fd_sc_hd__decap_3
XFILLER_25_11 VGND VGND VPWR VPWR sky130_fd_sc_hd__decap_3
Xrebuffer185 _350_/B VGND VGND VPWR VPWR rebuffer185/X sky130_fd_sc_hd__buf_2
Xrebuffer152 fanout105/X VGND VGND VPWR VPWR _610_/A sky130_fd_sc_hd__buf_2
Xrebuffer141 _633_/Y VGND VGND VPWR VPWR _651_/A1 sky130_fd_sc_hd__buf_2
Xrebuffer130 _657_/D VGND VGND VPWR VPWR _553_/A sky130_fd_sc_hd__buf_2
XFILLER_2_15 VGND VGND VPWR VPWR sky130_fd_sc_hd__decap_3
X_527_ _523_/B _589_/Y _588_/Y _526_/X VGND VGND VPWR VPWR _536_/A sky130_fd_sc_hd__o22a_2
XTAP_TAPCELL_ROW_19_138 VGND VPWR sky130_fd_sc_hd__tapvpwrvgnd_1
XFILLER_17_132 VGND VGND VPWR VPWR sky130_fd_sc_hd__decap_3
XFILLER_17_110 VGND VGND VPWR VPWR sky130_fd_sc_hd__fill_2
X_458_ _460_/B _460_/C _586_/Y VGND VGND VPWR VPWR _461_/A sky130_fd_sc_hd__a21o_2
X_389_ _389_/A _529_/A VGND VGND VPWR VPWR _389_/Y sky130_fd_sc_hd__nor2_2
XFILLER_32_168 VGND VGND VPWR VPWR sky130_fd_sc_hd__decap_3
XTAP_TAPCELL_ROW_2_80 VGND VPWR sky130_fd_sc_hd__tapvpwrvgnd_1
XFILLER_31_190 VGND VGND VPWR VPWR sky130_fd_sc_hd__decap_3
XFILLER_11_57 VGND VGND VPWR VPWR sky130_fd_sc_hd__decap_3
Xinput18 A[25] VGND VGND VPWR VPWR input18/X sky130_fd_sc_hd__clkdlybuf4s25_1
XFILLER_14_124 VGND VGND VPWR VPWR sky130_fd_sc_hd__fill_2
Xinput29 A[6] VGND VGND VPWR VPWR _634_/B1 sky130_fd_sc_hd__clkdlybuf4s25_1
XTAP_TAPCELL_ROW_30_177 VGND VPWR sky130_fd_sc_hd__tapvpwrvgnd_1
XFILLER_20_127 VGND VGND VPWR VPWR sky130_fd_sc_hd__decap_3
XFILLER_11_116 VGND VGND VPWR VPWR sky130_fd_sc_hd__decap_3
XFILLER_8_47 VGND VGND VPWR VPWR sky130_fd_sc_hd__decap_3
XFILLER_6_197 VGND VGND VPWR VPWR sky130_fd_sc_hd__decap_3
XFILLER_17_89 VGND VGND VPWR VPWR sky130_fd_sc_hd__decap_3
XFILLER_3_123 VGND VGND VPWR VPWR sky130_fd_sc_hd__decap_3
XFILLER_30_200 VGND VGND VPWR VPWR sky130_fd_sc_hd__fill_2
XPHY_EDGE_ROW_29_Left_63 VGND VGND VPWR VPWR sky130_fd_sc_hd__decap_3
XPHY_EDGE_ROW_13_Left_47 VGND VGND VPWR VPWR sky130_fd_sc_hd__decap_3
X_560_ _561_/B _561_/C _561_/A VGND VGND VPWR VPWR _563_/C sky130_fd_sc_hd__o21a_2
XFILLER_28_22 VGND VGND VPWR VPWR sky130_fd_sc_hd__decap_3
X_491_ _492_/C _492_/A VGND VGND VPWR VPWR _495_/B sky130_fd_sc_hd__nand2_2
XFILLER_12_200 VGND VGND VPWR VPWR sky130_fd_sc_hd__fill_2
XPHY_EDGE_ROW_13_Right_13 VGND VGND VPWR VPWR sky130_fd_sc_hd__decap_3
XTAP_TAPCELL_ROW_5_91 VGND VPWR sky130_fd_sc_hd__tapvpwrvgnd_1
XPHY_EDGE_ROW_22_Right_22 VGND VGND VPWR VPWR sky130_fd_sc_hd__decap_3
XPHY_EDGE_ROW_31_Right_31 VGND VGND VPWR VPWR sky130_fd_sc_hd__decap_3
XFILLER_30_12 VGND VGND VPWR VPWR sky130_fd_sc_hd__decap_3
XFILLER_14_68 VGND VGND VPWR VPWR sky130_fd_sc_hd__fill_1
X_543_ _536_/X _525_/Y _542_/X VGND VGND VPWR VPWR _543_/Y sky130_fd_sc_hd__a21oi_4
X_612_ _335_/A _608_/A _617_/A1 VGND VGND VPWR VPWR _612_/Y sky130_fd_sc_hd__o21ai_2
XFILLER_29_196 VGND VGND VPWR VPWR sky130_fd_sc_hd__decap_3
X_474_ _424_/Y _474_/A2 _473_/Y VGND VGND VPWR VPWR _474_/Y sky130_fd_sc_hd__a21oi_2
XFILLER_6_91 VGND VGND VPWR VPWR sky130_fd_sc_hd__decap_3
XPHY_EDGE_ROW_16_Left_50 VGND VGND VPWR VPWR sky130_fd_sc_hd__decap_3
XFILLER_26_133 VGND VGND VPWR VPWR sky130_fd_sc_hd__decap_3
XFILLER_26_177 VGND VGND VPWR VPWR sky130_fd_sc_hd__fill_2
Xrebuffer153 _597_/A VGND VGND VPWR VPWR _602_/A1 sky130_fd_sc_hd__buf_2
Xrebuffer131 _342_/Y VGND VGND VPWR VPWR _549_/A2 sky130_fd_sc_hd__buf_6
Xrebuffer120 _500_/D VGND VGND VPWR VPWR _506_/A3 sky130_fd_sc_hd__buf_2
X_526_ _523_/B _589_/Y _517_/B VGND VGND VPWR VPWR _526_/X sky130_fd_sc_hd__a21o_2
XTAP_TAPCELL_ROW_19_139 VGND VPWR sky130_fd_sc_hd__tapvpwrvgnd_1
XFILLER_17_199 VGND VGND VPWR VPWR sky130_fd_sc_hd__decap_3
X_457_ _625_/A _457_/B VGND VGND VPWR VPWR _460_/C sky130_fd_sc_hd__nand2_2
X_388_ _389_/A _529_/A VGND VGND VPWR VPWR _390_/C sky130_fd_sc_hd__nand2_2
XTAP_TAPCELL_ROW_2_81 VGND VPWR sky130_fd_sc_hd__tapvpwrvgnd_1
XFILLER_23_169 VGND VGND VPWR VPWR sky130_fd_sc_hd__fill_2
XFILLER_11_69 VGND VGND VPWR VPWR sky130_fd_sc_hd__decap_3
XFILLER_2_9 VGND VGND VPWR VPWR sky130_fd_sc_hd__decap_3
XPHY_EDGE_ROW_1_Left_35 VGND VGND VPWR VPWR sky130_fd_sc_hd__decap_3
XFILLER_14_103 VGND VGND VPWR VPWR sky130_fd_sc_hd__decap_3
Xinput19 A[26] VGND VGND VPWR VPWR _495_/A sky130_fd_sc_hd__clkdlybuf4s25_1
X_509_ _504_/A _504_/B _501_/Y VGND VGND VPWR VPWR _509_/X sky130_fd_sc_hd__o21a_2
XFILLER_20_139 VGND VGND VPWR VPWR sky130_fd_sc_hd__fill_1
XTAP_TAPCELL_ROW_30_178 VGND VPWR sky130_fd_sc_hd__tapvpwrvgnd_1
XTAP_TAPCELL_ROW_21_145 VGND VPWR sky130_fd_sc_hd__tapvpwrvgnd_1
XFILLER_22_35 VGND VGND VPWR VPWR sky130_fd_sc_hd__decap_3
XFILLER_11_139 VGND VGND VPWR VPWR sky130_fd_sc_hd__decap_3
XFILLER_22_68 VGND VGND VPWR VPWR sky130_fd_sc_hd__fill_1
XFILLER_0_6 VGND VGND VPWR VPWR sky130_fd_sc_hd__decap_3
XFILLER_6_154 VGND VGND VPWR VPWR sky130_fd_sc_hd__decap_3
XFILLER_33_23 VGND VGND VPWR VPWR sky130_fd_sc_hd__decap_3
XFILLER_17_57 VGND VGND VPWR VPWR sky130_fd_sc_hd__decap_3
XFILLER_31_3 VGND VGND VPWR VPWR sky130_fd_sc_hd__fill_2
XFILLER_0_138 VGND VGND VPWR VPWR sky130_fd_sc_hd__fill_2
XFILLER_28_67 VGND VGND VPWR VPWR sky130_fd_sc_hd__fill_2
XFILLER_28_56 VGND VGND VPWR VPWR sky130_fd_sc_hd__decap_3
X_490_ _490_/A _490_/B VGND VGND VPWR VPWR _492_/A sky130_fd_sc_hd__or2_2
XPHY_EDGE_ROW_30_Left_64 VGND VGND VPWR VPWR sky130_fd_sc_hd__decap_3
XFILLER_5_27 VGND VGND VPWR VPWR sky130_fd_sc_hd__fill_2
XFILLER_30_57 VGND VGND VPWR VPWR sky130_fd_sc_hd__fill_1
XFILLER_30_24 VGND VGND VPWR VPWR sky130_fd_sc_hd__decap_3
X_473_ _448_/Y _459_/X _462_/Y _461_/A VGND VGND VPWR VPWR _473_/Y sky130_fd_sc_hd__o31ai_2
X_542_ _532_/A _532_/B _540_/Y _541_/X VGND VGND VPWR VPWR _542_/X sky130_fd_sc_hd__a2bb2o_2
X_611_ _625_/A _608_/A _617_/A1 VGND VGND VPWR VPWR _611_/Y sky130_fd_sc_hd__a21oi_2
XFILLER_29_175 VGND VGND VPWR VPWR sky130_fd_sc_hd__decap_3
XFILLER_26_167 VGND VGND VPWR VPWR sky130_fd_sc_hd__decap_3
Xrebuffer132 _335_/A VGND VGND VPWR VPWR _616_/A1 sky130_fd_sc_hd__buf_2
Xrebuffer121 _393_/B VGND VGND VPWR VPWR _420_/A sky130_fd_sc_hd__buf_2
XFILLER_25_57 VGND VGND VPWR VPWR sky130_fd_sc_hd__fill_1
Xrebuffer198 _324_/A VGND VGND VPWR VPWR _546_/B sky130_fd_sc_hd__buf_6
Xrebuffer154 _429_/A VGND VGND VPWR VPWR _428_/A sky130_fd_sc_hd__buf_2
XFILLER_9_3 VGND VGND VPWR VPWR sky130_fd_sc_hd__decap_3
XFILLER_17_101 VGND VGND VPWR VPWR sky130_fd_sc_hd__decap_3
X_456_ _457_/B _580_/A VGND VGND VPWR VPWR _460_/B sky130_fd_sc_hd__nand2b_2
X_525_ _525_/A _525_/B _525_/C VGND VGND VPWR VPWR _525_/Y sky130_fd_sc_hd__nand3_4
XFILLER_17_167 VGND VGND VPWR VPWR sky130_fd_sc_hd__fill_1
XFILLER_17_123 VGND VGND VPWR VPWR sky130_fd_sc_hd__decap_3
X_387_ _389_/A _529_/A VGND VGND VPWR VPWR _387_/X sky130_fd_sc_hd__and2_2
XFILLER_15_90 VGND VGND VPWR VPWR sky130_fd_sc_hd__decap_3
XTAP_TAPCELL_ROW_33_187 VGND VPWR sky130_fd_sc_hd__tapvpwrvgnd_1
XFILLER_23_126 VGND VGND VPWR VPWR sky130_fd_sc_hd__decap_3
XFILLER_11_48 VGND VGND VPWR VPWR sky130_fd_sc_hd__decap_3
XFILLER_14_159 VGND VGND VPWR VPWR sky130_fd_sc_hd__fill_1
XFILLER_14_115 VGND VGND VPWR VPWR sky130_fd_sc_hd__decap_3
XFILLER_22_192 VGND VGND VPWR VPWR sky130_fd_sc_hd__decap_3
XFILLER_22_170 VGND VGND VPWR VPWR sky130_fd_sc_hd__decap_3
X_439_ _452_/C _452_/D VGND VGND VPWR VPWR _441_/A sky130_fd_sc_hd__nand2_2
X_508_ _486_/Y _508_/B _508_/C VGND VGND VPWR VPWR _513_/B sky130_fd_sc_hd__nand3b_2
XFILLER_9_130 VGND VGND VPWR VPWR sky130_fd_sc_hd__fill_2
XFILLER_20_118 VGND VGND VPWR VPWR sky130_fd_sc_hd__decap_3
XTAP_TAPCELL_ROW_30_179 VGND VPWR sky130_fd_sc_hd__tapvpwrvgnd_1
XTAP_TAPCELL_ROW_21_146 VGND VPWR sky130_fd_sc_hd__tapvpwrvgnd_1
XFILLER_22_47 VGND VGND VPWR VPWR sky130_fd_sc_hd__decap_3
XTAP_TAPCELL_ROW_12_113 VGND VPWR sky130_fd_sc_hd__tapvpwrvgnd_1
XFILLER_8_27 VGND VGND VPWR VPWR sky130_fd_sc_hd__fill_1
XFILLER_12_91 VGND VGND VPWR VPWR sky130_fd_sc_hd__decap_3
XFILLER_33_57 VGND VGND VPWR VPWR sky130_fd_sc_hd__fill_2
XFILLER_9_92 VGND VGND VPWR VPWR sky130_fd_sc_hd__decap_3
XPHY_EDGE_ROW_7_Right_7 VGND VGND VPWR VPWR sky130_fd_sc_hd__decap_3
X_610_ _610_/A _608_/A VGND VGND VPWR VPWR _610_/Y sky130_fd_sc_hd__nor2b_2
XFILLER_29_110 VGND VGND VPWR VPWR sky130_fd_sc_hd__fill_2
X_472_ _472_/A _472_/B _472_/C VGND VGND VPWR VPWR _475_/B sky130_fd_sc_hd__nor3_4
X_541_ _590_/A _541_/B VGND VGND VPWR VPWR _541_/X sky130_fd_sc_hd__or2_2
XFILLER_29_165 VGND VGND VPWR VPWR sky130_fd_sc_hd__decap_3
XFILLER_20_91 VGND VGND VPWR VPWR sky130_fd_sc_hd__decap_3
XFILLER_26_124 VGND VGND VPWR VPWR sky130_fd_sc_hd__decap_3
XFILLER_25_14 VGND VGND VPWR VPWR sky130_fd_sc_hd__fill_1
Xrebuffer155 fanout113/X VGND VGND VPWR VPWR _614_/B sky130_fd_sc_hd__buf_2
Xrebuffer133 _602_/Y VGND VGND VPWR VPWR _569_/A1 sky130_fd_sc_hd__buf_2
Xrebuffer122 _571_/B VGND VGND VPWR VPWR _573_/A2 sky130_fd_sc_hd__buf_2
Xrebuffer177 _341_/C VGND VGND VPWR VPWR _318_/A sky130_fd_sc_hd__buf_2
Xrebuffer166 rebuffer185/X VGND VGND VPWR VPWR _348_/A1 sky130_fd_sc_hd__buf_6
XFILLER_2_29 VGND VGND VPWR VPWR sky130_fd_sc_hd__fill_1
XFILLER_2_18 VGND VGND VPWR VPWR sky130_fd_sc_hd__decap_3
XFILLER_17_135 VGND VGND VPWR VPWR sky130_fd_sc_hd__decap_3
XFILLER_17_113 VGND VGND VPWR VPWR sky130_fd_sc_hd__fill_2
X_455_ _455_/A _472_/B VGND VGND VPWR VPWR _455_/X sky130_fd_sc_hd__xor2_2
X_524_ _524_/A _524_/B VGND VGND VPWR VPWR _524_/Y sky130_fd_sc_hd__xnor2_2
X_386_ _376_/Y _383_/X _571_/B _380_/X VGND VGND VPWR VPWR _393_/B sky130_fd_sc_hd__o22ai_4
Xoutput90 _544_/Y VGND VGND VPWR VPWR S[31] sky130_fd_sc_hd__buf_6
XTAP_TAPCELL_ROW_33_188 VGND VPWR sky130_fd_sc_hd__tapvpwrvgnd_1
XFILLER_31_193 VGND VGND VPWR VPWR sky130_fd_sc_hd__fill_1
XTAP_TAPCELL_ROW_24_155 VGND VPWR sky130_fd_sc_hd__tapvpwrvgnd_1
XFILLER_22_160 VGND VGND VPWR VPWR sky130_fd_sc_hd__decap_3
X_438_ _434_/Y _435_/X input14/X VGND VGND VPWR VPWR _452_/D sky130_fd_sc_hd__o21bai_4
X_507_ _507_/A _507_/B VGND VGND VPWR VPWR _507_/Y sky130_fd_sc_hd__nand2_4
X_369_ _369_/A _369_/B VGND VGND VPWR VPWR _369_/Y sky130_fd_sc_hd__nor2_2
XFILLER_20_108 VGND VGND VPWR VPWR sky130_fd_sc_hd__decap_3
XFILLER_11_119 VGND VGND VPWR VPWR sky130_fd_sc_hd__fill_1
XTAP_TAPCELL_ROW_21_147 VGND VPWR sky130_fd_sc_hd__tapvpwrvgnd_1
Xfanout110 _539_/A VGND VGND VPWR VPWR _629_/A1 sky130_fd_sc_hd__buf_4
XTAP_TAPCELL_ROW_12_114 VGND VPWR sky130_fd_sc_hd__tapvpwrvgnd_1
XFILLER_10_152 VGND VGND VPWR VPWR sky130_fd_sc_hd__decap_3
XFILLER_10_141 VGND VGND VPWR VPWR sky130_fd_sc_hd__fill_2
XFILLER_6_112 VGND VGND VPWR VPWR sky130_fd_sc_hd__decap_3
XFILLER_12_81 VGND VGND VPWR VPWR sky130_fd_sc_hd__decap_3
XFILLER_33_200 VGND VGND VPWR VPWR sky130_fd_sc_hd__fill_2
XFILLER_24_200 VGND VGND VPWR VPWR sky130_fd_sc_hd__fill_2
XFILLER_33_69 VGND VGND VPWR VPWR sky130_fd_sc_hd__decap_3
XFILLER_3_126 VGND VGND VPWR VPWR sky130_fd_sc_hd__decap_3
XFILLER_9_60 VGND VGND VPWR VPWR sky130_fd_sc_hd__decap_3
XFILLER_28_25 VGND VGND VPWR VPWR sky130_fd_sc_hd__decap_3
XFILLER_18_91 VGND VGND VPWR VPWR sky130_fd_sc_hd__decap_3
XFILLER_30_15 VGND VGND VPWR VPWR sky130_fd_sc_hd__fill_1
X_540_ _590_/A _541_/B VGND VGND VPWR VPWR _540_/Y sky130_fd_sc_hd__nand2_2
X_471_ _471_/A _487_/A VGND VGND VPWR VPWR _500_/A sky130_fd_sc_hd__or2_2
XFILLER_29_199 VGND VGND VPWR VPWR sky130_fd_sc_hd__decap_3
XFILLER_20_70 VGND VGND VPWR VPWR sky130_fd_sc_hd__decap_3
XFILLER_6_94 VGND VGND VPWR VPWR sky130_fd_sc_hd__decap_3
XFILLER_26_103 VGND VGND VPWR VPWR sky130_fd_sc_hd__decap_3
XFILLER_26_136 VGND VGND VPWR VPWR sky130_fd_sc_hd__decap_3
Xrebuffer178 rebuffer206/X VGND VGND VPWR VPWR _324_/C sky130_fd_sc_hd__buf_6
Xrebuffer156 _380_/D VGND VGND VPWR VPWR _577_/A1 sky130_fd_sc_hd__buf_2
Xrebuffer134 _435_/A VGND VGND VPWR VPWR _444_/A sky130_fd_sc_hd__buf_2
Xrebuffer123 _624_/A VGND VGND VPWR VPWR _352_/B1 sky130_fd_sc_hd__buf_2
X_523_ _589_/A _523_/B VGND VGND VPWR VPWR _524_/B sky130_fd_sc_hd__xor2_2
XFILLER_17_169 VGND VGND VPWR VPWR sky130_fd_sc_hd__decap_3
X_454_ _452_/D _451_/Y _433_/A _463_/A VGND VGND VPWR VPWR _455_/A sky130_fd_sc_hd__a22oi_4
X_385_ _378_/B _384_/Y _379_/Y _352_/Y VGND VGND VPWR VPWR _385_/Y sky130_fd_sc_hd__a22oi_4
XFILLER_32_139 VGND VGND VPWR VPWR sky130_fd_sc_hd__fill_1
XFILLER_15_81 VGND VGND VPWR VPWR sky130_fd_sc_hd__decap_3
Xoutput91 _552_/X VGND VGND VPWR VPWR S[3] sky130_fd_sc_hd__buf_6
Xoutput80 _455_/X VGND VGND VPWR VPWR S[22] sky130_fd_sc_hd__buf_6
XTAP_TAPCELL_ROW_33_189 VGND VPWR sky130_fd_sc_hd__tapvpwrvgnd_1
XTAP_TAPCELL_ROW_24_156 VGND VPWR sky130_fd_sc_hd__tapvpwrvgnd_1
XFILLER_14_139 VGND VGND VPWR VPWR sky130_fd_sc_hd__fill_1
XFILLER_14_106 VGND VGND VPWR VPWR sky130_fd_sc_hd__decap_3
X_506_ _486_/Y _500_/C _506_/A3 _502_/X _508_/C VGND VGND VPWR VPWR _507_/B sky130_fd_sc_hd__o311ai_4
X_437_ _444_/A _435_/B _436_/Y VGND VGND VPWR VPWR _452_/C sky130_fd_sc_hd__o21ai_2
X_368_ _369_/A _369_/B VGND VGND VPWR VPWR _370_/C sky130_fd_sc_hd__nand2_2
XFILLER_9_121 VGND VGND VPWR VPWR sky130_fd_sc_hd__fill_1
XPHY_EDGE_ROW_5_Left_39 VGND VGND VPWR VPWR sky130_fd_sc_hd__decap_3
XFILLER_22_38 VGND VGND VPWR VPWR sky130_fd_sc_hd__decap_3
Xfanout100 _435_/A VGND VGND VPWR VPWR _429_/A sky130_fd_sc_hd__buf_8
XFILLER_0_9 VGND VGND VPWR VPWR sky130_fd_sc_hd__decap_3
XPHY_EDGE_ROW_29_Right_29 VGND VGND VPWR VPWR sky130_fd_sc_hd__decap_3
XTAP_TAPCELL_ROW_12_115 VGND VPWR sky130_fd_sc_hd__tapvpwrvgnd_1
XFILLER_8_29 VGND VGND VPWR VPWR sky130_fd_sc_hd__decap_3
XFILLER_6_157 VGND VGND VPWR VPWR sky130_fd_sc_hd__fill_2
XFILLER_12_60 VGND VGND VPWR VPWR sky130_fd_sc_hd__decap_3
XFILLER_10_197 VGND VGND VPWR VPWR sky130_fd_sc_hd__decap_3
XFILLER_17_49 VGND VGND VPWR VPWR sky130_fd_sc_hd__fill_2
XFILLER_33_26 VGND VGND VPWR VPWR sky130_fd_sc_hd__fill_2
XFILLER_0_85 VGND VGND VPWR VPWR sky130_fd_sc_hd__decap_3
XFILLER_9_72 VGND VGND VPWR VPWR sky130_fd_sc_hd__decap_3
XFILLER_9_50 VGND VGND VPWR VPWR sky130_fd_sc_hd__decap_3
XFILLER_0_108 VGND VGND VPWR VPWR sky130_fd_sc_hd__decap_3
XFILLER_28_59 VGND VGND VPWR VPWR sky130_fd_sc_hd__fill_1
XFILLER_5_19 VGND VGND VPWR VPWR sky130_fd_sc_hd__fill_1
XPHY_EDGE_ROW_8_Left_42 VGND VGND VPWR VPWR sky130_fd_sc_hd__decap_3
XFILLER_18_81 VGND VGND VPWR VPWR sky130_fd_sc_hd__decap_3
Xload_slew111 _629_/A1 VGND VGND VPWR VPWR _638_/A sky130_fd_sc_hd__buf_6
XFILLER_30_27 VGND VGND VPWR VPWR sky130_fd_sc_hd__fill_1
XFILLER_14_39 VGND VGND VPWR VPWR sky130_fd_sc_hd__fill_2
XFILLER_29_178 VGND VGND VPWR VPWR sky130_fd_sc_hd__decap_3
XFILLER_29_134 VGND VGND VPWR VPWR sky130_fd_sc_hd__decap_3
X_470_ _470_/A _587_/Y _470_/C VGND VGND VPWR VPWR _486_/B sky130_fd_sc_hd__or3_2
XFILLER_20_82 VGND VGND VPWR VPWR sky130_fd_sc_hd__fill_2
X_599_ _598_/B _599_/B VGND VGND VPWR VPWR _605_/C sky130_fd_sc_hd__nand2b_2
Xrebuffer179 _350_/A VGND VGND VPWR VPWR _347_/B sky130_fd_sc_hd__buf_6
Xrebuffer157 _380_/D VGND VGND VPWR VPWR _574_/A sky130_fd_sc_hd__buf_2
Xrebuffer146 _623_/C VGND VGND VPWR VPWR _561_/A sky130_fd_sc_hd__buf_2
Xrebuffer135 _435_/A VGND VGND VPWR VPWR _658_/B sky130_fd_sc_hd__buf_2
Xrebuffer124 _350_/B VGND VGND VPWR VPWR _347_/A sky130_fd_sc_hd__buf_2
X_453_ _472_/A VGND VGND VPWR VPWR _463_/A sky130_fd_sc_hd__inv_2
X_522_ _589_/Y _523_/B VGND VGND VPWR VPWR _525_/C sky130_fd_sc_hd__xor2_2
XFILLER_17_126 VGND VGND VPWR VPWR sky130_fd_sc_hd__decap_3
XFILLER_17_104 VGND VGND VPWR VPWR sky130_fd_sc_hd__decap_3
X_384_ _384_/A _384_/B VGND VGND VPWR VPWR _384_/Y sky130_fd_sc_hd__nand2_2
XFILLER_15_93 VGND VGND VPWR VPWR sky130_fd_sc_hd__decap_3
XFILLER_15_60 VGND VGND VPWR VPWR sky130_fd_sc_hd__decap_3
Xoutput70 _574_/Y VGND VGND VPWR VPWR S[13] sky130_fd_sc_hd__clkbuf_4
Xoutput92 _553_/X VGND VGND VPWR VPWR S[4] sky130_fd_sc_hd__clkbuf_2
Xoutput81 _465_/X VGND VGND VPWR VPWR S[23] sky130_fd_sc_hd__buf_6
XFILLER_23_129 VGND VGND VPWR VPWR sky130_fd_sc_hd__decap_3
XFILLER_14_118 VGND VGND VPWR VPWR sky130_fd_sc_hd__decap_3
XTAP_TAPCELL_ROW_24_157 VGND VPWR sky130_fd_sc_hd__tapvpwrvgnd_1
XFILLER_22_195 VGND VGND VPWR VPWR sky130_fd_sc_hd__fill_1
X_436_ _444_/A _435_/B input14/X VGND VGND VPWR VPWR _436_/Y sky130_fd_sc_hd__a21boi_2
X_505_ _500_/Y _501_/Y _508_/C VGND VGND VPWR VPWR _507_/A sky130_fd_sc_hd__o21bai_2
XTAP_TAPCELL_ROW_15_124 VGND VPWR sky130_fd_sc_hd__tapvpwrvgnd_1
X_367_ _369_/A _369_/B VGND VGND VPWR VPWR _367_/X sky130_fd_sc_hd__and2_4
XPHY_EDGE_ROW_21_Left_55 VGND VGND VPWR VPWR sky130_fd_sc_hd__decap_3
XFILLER_9_177 VGND VGND VPWR VPWR sky130_fd_sc_hd__fill_2
XFILLER_9_111 VGND VGND VPWR VPWR sky130_fd_sc_hd__fill_1
Xfanout112 fanout113/X VGND VGND VPWR VPWR _631_/B sky130_fd_sc_hd__buf_8
XTAP_TAPCELL_ROW_12_116 VGND VPWR sky130_fd_sc_hd__tapvpwrvgnd_1
XFILLER_12_72 VGND VGND VPWR VPWR sky130_fd_sc_hd__decap_3
XFILLER_10_132 VGND VGND VPWR VPWR sky130_fd_sc_hd__decap_3
XFILLER_12_94 VGND VGND VPWR VPWR sky130_fd_sc_hd__decap_3
X_419_ _425_/C _419_/B VGND VGND VPWR VPWR _475_/D sky130_fd_sc_hd__nor2_4
XFILLER_23_93 VGND VGND VPWR VPWR sky130_fd_sc_hd__decap_3
XFILLER_23_71 VGND VGND VPWR VPWR sky130_fd_sc_hd__decap_3
XFILLER_9_95 VGND VGND VPWR VPWR sky130_fd_sc_hd__decap_3
Xload_slew101 _429_/A VGND VGND VPWR VPWR _319_/A sky130_fd_sc_hd__buf_8
XFILLER_22_3 VGND VGND VPWR VPWR sky130_fd_sc_hd__fill_2
XFILLER_29_113 VGND VGND VPWR VPWR sky130_fd_sc_hd__decap_3
XFILLER_4_201 VGND VGND VPWR VPWR sky130_fd_sc_hd__fill_1
XFILLER_20_94 VGND VGND VPWR VPWR sky130_fd_sc_hd__decap_3
XFILLER_20_61 VGND VGND VPWR VPWR sky130_fd_sc_hd__decap_3
XFILLER_29_81 VGND VGND VPWR VPWR sky130_fd_sc_hd__decap_3
X_598_ _599_/B _598_/B VGND VGND VPWR VPWR _605_/B sky130_fd_sc_hd__nand2b_4
XFILLER_6_85 VGND VGND VPWR VPWR sky130_fd_sc_hd__decap_3
XFILLER_26_127 VGND VGND VPWR VPWR sky130_fd_sc_hd__decap_3
Xrebuffer147 _322_/Y VGND VGND VPWR VPWR _545_/A2 sky130_fd_sc_hd__buf_2
Xrebuffer125 _623_/A VGND VGND VPWR VPWR _570_/A sky130_fd_sc_hd__buf_2
X_452_ _452_/A _452_/B _452_/C _452_/D VGND VGND VPWR VPWR _472_/A sky130_fd_sc_hd__nand4_4
X_521_ _521_/A _521_/B VGND VGND VPWR VPWR _523_/B sky130_fd_sc_hd__xnor2_2
X_383_ _384_/A _384_/B VGND VGND VPWR VPWR _383_/X sky130_fd_sc_hd__and2_2
XTAP_TAPCELL_ROW_27_166 VGND VPWR sky130_fd_sc_hd__tapvpwrvgnd_1
XFILLER_17_138 VGND VGND VPWR VPWR sky130_fd_sc_hd__decap_3
XFILLER_15_72 VGND VGND VPWR VPWR sky130_fd_sc_hd__decap_3
Xoutput93 _555_/Y VGND VGND VPWR VPWR S[5] sky130_fd_sc_hd__clkbuf_4
Xoutput82 _478_/X VGND VGND VPWR VPWR S[24] sky130_fd_sc_hd__buf_6
Xoutput71 _576_/Y VGND VGND VPWR VPWR S[14] sky130_fd_sc_hd__buf_6
XTAP_TAPCELL_ROW_24_158 VGND VPWR sky130_fd_sc_hd__tapvpwrvgnd_1
X_504_ _504_/A _504_/B VGND VGND VPWR VPWR _508_/C sky130_fd_sc_hd__xor2_2
X_435_ _435_/A _435_/B VGND VGND VPWR VPWR _435_/X sky130_fd_sc_hd__and2_4
X_366_ _366_/A _366_/B VGND VGND VPWR VPWR _380_/B sky130_fd_sc_hd__nand2_4
XTAP_TAPCELL_ROW_15_125 VGND VPWR sky130_fd_sc_hd__tapvpwrvgnd_1
XFILLER_13_141 VGND VGND VPWR VPWR sky130_fd_sc_hd__decap_3
XFILLER_3_64 VGND VGND VPWR VPWR sky130_fd_sc_hd__fill_2
XFILLER_3_31 VGND VGND VPWR VPWR sky130_fd_sc_hd__fill_1
Xfanout102 fanout105/X VGND VGND VPWR VPWR _435_/A sky130_fd_sc_hd__buf_8
Xfanout113 _539_/A VGND VGND VPWR VPWR fanout113/X sky130_fd_sc_hd__buf_6
XFILLER_6_137 VGND VGND VPWR VPWR sky130_fd_sc_hd__decap_3
XFILLER_12_51 VGND VGND VPWR VPWR sky130_fd_sc_hd__decap_3
XFILLER_10_155 VGND VGND VPWR VPWR sky130_fd_sc_hd__fill_2
XFILLER_18_200 VGND VGND VPWR VPWR sky130_fd_sc_hd__fill_2
X_418_ _475_/C _475_/A VGND VGND VPWR VPWR _425_/D sky130_fd_sc_hd__nand2_2
X_349_ _657_/Y _624_/A _619_/Y VGND VGND VPWR VPWR _349_/Y sky130_fd_sc_hd__o21ai_4
XFILLER_3_129 VGND VGND VPWR VPWR sky130_fd_sc_hd__fill_1
XFILLER_23_50 VGND VGND VPWR VPWR sky130_fd_sc_hd__decap_3
XFILLER_0_21 VGND VGND VPWR VPWR sky130_fd_sc_hd__decap_3
XFILLER_9_63 VGND VGND VPWR VPWR sky130_fd_sc_hd__decap_3
XFILLER_18_94 VGND VGND VPWR VPWR sky130_fd_sc_hd__decap_3
XFILLER_30_29 VGND VGND VPWR VPWR sky130_fd_sc_hd__decap_3
XFILLER_29_169 VGND VGND VPWR VPWR sky130_fd_sc_hd__decap_3
XFILLER_20_73 VGND VGND VPWR VPWR sky130_fd_sc_hd__decap_3
XFILLER_29_60 VGND VGND VPWR VPWR sky130_fd_sc_hd__fill_2
X_597_ _597_/A _598_/B VGND VGND VPWR VPWR _603_/B sky130_fd_sc_hd__nand2_2
XFILLER_28_191 VGND VGND VPWR VPWR sky130_fd_sc_hd__decap_3
XFILLER_6_97 VGND VGND VPWR VPWR sky130_fd_sc_hd__fill_2
XFILLER_26_139 VGND VGND VPWR VPWR sky130_fd_sc_hd__fill_1
XFILLER_26_106 VGND VGND VPWR VPWR sky130_fd_sc_hd__fill_2
Xrebuffer137 _657_/B VGND VGND VPWR VPWR _557_/A sky130_fd_sc_hd__buf_2
Xrebuffer126 _653_/Y VGND VGND VPWR VPWR _561_/B sky130_fd_sc_hd__buf_2
Xrebuffer148 _475_/B VGND VGND VPWR VPWR _474_/A2 sky130_fd_sc_hd__buf_2
X_520_ _588_/Y _517_/B _518_/A _519_/A VGND VGND VPWR VPWR _524_/A sky130_fd_sc_hd__o22ai_2
X_451_ _452_/A _452_/C VGND VGND VPWR VPWR _451_/Y sky130_fd_sc_hd__nand2_2
X_382_ _381_/Y _372_/B _372_/A VGND VGND VPWR VPWR _384_/B sky130_fd_sc_hd__a21boi_2
XTAP_TAPCELL_ROW_27_167 VGND VPWR sky130_fd_sc_hd__tapvpwrvgnd_1
XFILLER_25_183 VGND VGND VPWR VPWR sky130_fd_sc_hd__decap_3
XFILLER_25_172 VGND VGND VPWR VPWR sky130_fd_sc_hd__decap_3
XFILLER_15_84 VGND VGND VPWR VPWR sky130_fd_sc_hd__decap_3
Xoutput94 _557_/X VGND VGND VPWR VPWR S[6] sky130_fd_sc_hd__clkbuf_2
Xoutput83 _485_/Y VGND VGND VPWR VPWR S[25] sky130_fd_sc_hd__buf_6
Xoutput72 _578_/Y VGND VGND VPWR VPWR S[15] sky130_fd_sc_hd__buf_6
X_649_ _647_/B _655_/A2 _648_/Y VGND VGND VPWR VPWR _649_/Y sky130_fd_sc_hd__a21oi_4
XTAP_TAPCELL_ROW_18_134 VGND VPWR sky130_fd_sc_hd__tapvpwrvgnd_1
XFILLER_23_109 VGND VGND VPWR VPWR sky130_fd_sc_hd__decap_3
XFILLER_22_131 VGND VGND VPWR VPWR sky130_fd_sc_hd__decap_3
XFILLER_14_109 VGND VGND VPWR VPWR sky130_fd_sc_hd__decap_3
XFILLER_22_197 VGND VGND VPWR VPWR sky130_fd_sc_hd__decap_3
X_503_ _503_/A _503_/B VGND VGND VPWR VPWR _504_/B sky130_fd_sc_hd__xor2_2
X_434_ _444_/A _435_/B VGND VGND VPWR VPWR _434_/Y sky130_fd_sc_hd__nor2_2
X_365_ _361_/X _363_/Y _364_/B VGND VGND VPWR VPWR _366_/A sky130_fd_sc_hd__o21bai_4
XTAP_TAPCELL_ROW_15_126 VGND VPWR sky130_fd_sc_hd__tapvpwrvgnd_1
XFILLER_9_113 VGND VGND VPWR VPWR sky130_fd_sc_hd__decap_3
XFILLER_13_131 VGND VGND VPWR VPWR sky130_fd_sc_hd__decap_3
Xfanout103 fanout105/X VGND VGND VPWR VPWR _580_/A sky130_fd_sc_hd__buf_4
XFILLER_10_112 VGND VGND VPWR VPWR sky130_fd_sc_hd__decap_3
XFILLER_10_101 VGND VGND VPWR VPWR sky130_fd_sc_hd__decap_3
XFILLER_12_85 VGND VGND VPWR VPWR sky130_fd_sc_hd__decap_3
XFILLER_12_63 VGND VGND VPWR VPWR sky130_fd_sc_hd__decap_3
XPHY_EDGE_ROW_16_Right_16 VGND VGND VPWR VPWR sky130_fd_sc_hd__decap_3
X_417_ _415_/A _415_/B _415_/C VGND VGND VPWR VPWR _475_/A sky130_fd_sc_hd__a21o_2
X_348_ _348_/A1 _347_/B _657_/Y VGND VGND VPWR VPWR _561_/C sky130_fd_sc_hd__a21oi_4
XPHY_EDGE_ROW_25_Right_25 VGND VGND VPWR VPWR sky130_fd_sc_hd__decap_3
XFILLER_5_182 VGND VGND VPWR VPWR sky130_fd_sc_hd__decap_3
XFILLER_33_29 VGND VGND VPWR VPWR sky130_fd_sc_hd__fill_2
XFILLER_9_53 VGND VGND VPWR VPWR sky130_fd_sc_hd__decap_3
XFILLER_0_88 VGND VGND VPWR VPWR sky130_fd_sc_hd__fill_1
XFILLER_28_29 VGND VGND VPWR VPWR sky130_fd_sc_hd__fill_2
XFILLER_18_51 VGND VGND VPWR VPWR sky130_fd_sc_hd__decap_3
Xload_slew114 fanout113/X VGND VGND VPWR VPWR _647_/B sky130_fd_sc_hd__buf_4
XPHY_EDGE_ROW_2_Right_2 VGND VGND VPWR VPWR sky130_fd_sc_hd__decap_3
XFILLER_29_137 VGND VGND VPWR VPWR sky130_fd_sc_hd__decap_3
XFILLER_20_85 VGND VGND VPWR VPWR sky130_fd_sc_hd__decap_3
XFILLER_20_41 VGND VGND VPWR VPWR sky130_fd_sc_hd__fill_1
XFILLER_29_72 VGND VGND VPWR VPWR sky130_fd_sc_hd__decap_3
XFILLER_28_170 VGND VGND VPWR VPWR sky130_fd_sc_hd__decap_3
X_596_ _591_/X _594_/Y _595_/Y VGND VGND VPWR VPWR _623_/A sky130_fd_sc_hd__o21a_4
Xrebuffer149 _316_/X VGND VGND VPWR VPWR _317_/A sky130_fd_sc_hd__buf_2
Xrebuffer138 _366_/B VGND VGND VPWR VPWR _575_/A2 sky130_fd_sc_hd__buf_2
Xrebuffer127 _352_/Y VGND VGND VPWR VPWR _572_/B sky130_fd_sc_hd__buf_4
XFILLER_17_129 VGND VGND VPWR VPWR sky130_fd_sc_hd__decap_3
XFILLER_17_107 VGND VGND VPWR VPWR sky130_fd_sc_hd__decap_3
X_450_ _463_/C _463_/B VGND VGND VPWR VPWR _472_/B sky130_fd_sc_hd__nand2_4
X_381_ _360_/A _575_/A2 _357_/Y VGND VGND VPWR VPWR _381_/Y sky130_fd_sc_hd__a21oi_2
XTAP_TAPCELL_ROW_27_168 VGND VPWR sky130_fd_sc_hd__tapvpwrvgnd_1
XFILLER_25_140 VGND VGND VPWR VPWR sky130_fd_sc_hd__decap_3
XFILLER_15_96 VGND VGND VPWR VPWR sky130_fd_sc_hd__decap_3
XFILLER_15_63 VGND VGND VPWR VPWR sky130_fd_sc_hd__decap_3
XFILLER_31_40 VGND VGND VPWR VPWR sky130_fd_sc_hd__decap_3
Xoutput95 _559_/Y VGND VGND VPWR VPWR S[7] sky130_fd_sc_hd__buf_6
Xoutput84 _499_/Y VGND VGND VPWR VPWR S[26] sky130_fd_sc_hd__buf_6
Xoutput73 _393_/Y VGND VGND VPWR VPWR S[16] sky130_fd_sc_hd__buf_6
X_648_ _647_/B _655_/A2 _655_/B1 VGND VGND VPWR VPWR _648_/Y sky130_fd_sc_hd__o21ai_4
XTAP_TAPCELL_ROW_18_135 VGND VPWR sky130_fd_sc_hd__tapvpwrvgnd_1
X_579_ _590_/Y _541_/B _543_/Y VGND VGND VPWR VPWR _579_/Y sky130_fd_sc_hd__o21bai_4
XTAP_TAPCELL_ROW_9_103 VGND VPWR sky130_fd_sc_hd__tapvpwrvgnd_1
X_502_ _486_/C _487_/Y _496_/A _493_/Y VGND VGND VPWR VPWR _502_/X sky130_fd_sc_hd__a31o_2
X_433_ _433_/A _433_/B VGND VGND VPWR VPWR _433_/Y sky130_fd_sc_hd__xnor2_2
X_364_ _363_/Y _364_/B _364_/C VGND VGND VPWR VPWR _366_/B sky130_fd_sc_hd__nand3b_4
XFILLER_9_169 VGND VGND VPWR VPWR sky130_fd_sc_hd__fill_1
Xfanout115 _539_/A VGND VGND VPWR VPWR _369_/A sky130_fd_sc_hd__buf_4
XFILLER_10_146 VGND VGND VPWR VPWR sky130_fd_sc_hd__decap_3
XFILLER_10_135 VGND VGND VPWR VPWR sky130_fd_sc_hd__decap_3
XTAP_TAPCELL_ROW_20_141 VGND VPWR sky130_fd_sc_hd__tapvpwrvgnd_1
XFILLER_5_3 VGND VGND VPWR VPWR sky130_fd_sc_hd__fill_2
XFILLER_12_97 VGND VGND VPWR VPWR sky130_fd_sc_hd__decap_3
XFILLER_12_75 VGND VGND VPWR VPWR sky130_fd_sc_hd__decap_3
XFILLER_10_179 VGND VGND VPWR VPWR sky130_fd_sc_hd__fill_1
XPHY_EDGE_ROW_25_Left_59 VGND VGND VPWR VPWR sky130_fd_sc_hd__decap_3
X_416_ _415_/A _415_/B _415_/C VGND VGND VPWR VPWR _416_/Y sky130_fd_sc_hd__a21oi_2
X_347_ _347_/A _347_/B VGND VGND VPWR VPWR _553_/B sky130_fd_sc_hd__nand2_8
XFILLER_5_150 VGND VGND VPWR VPWR sky130_fd_sc_hd__decap_3
XFILLER_23_74 VGND VGND VPWR VPWR sky130_fd_sc_hd__fill_1
XFILLER_23_41 VGND VGND VPWR VPWR sky130_fd_sc_hd__decap_3
XFILLER_2_197 VGND VGND VPWR VPWR sky130_fd_sc_hd__decap_3
XFILLER_0_12 VGND VGND VPWR VPWR sky130_fd_sc_hd__decap_3
XFILLER_18_85 VGND VGND VPWR VPWR sky130_fd_sc_hd__decap_3
Xload_slew104 _580_/A VGND VGND VPWR VPWR _335_/A sky130_fd_sc_hd__buf_8
XPHY_EDGE_ROW_28_Left_62 VGND VGND VPWR VPWR sky130_fd_sc_hd__decap_3
XPHY_EDGE_ROW_12_Left_46 VGND VGND VPWR VPWR sky130_fd_sc_hd__decap_3
XFILLER_29_149 VGND VGND VPWR VPWR sky130_fd_sc_hd__fill_2
XFILLER_29_116 VGND VGND VPWR VPWR sky130_fd_sc_hd__decap_3
XFILLER_20_97 VGND VGND VPWR VPWR sky130_fd_sc_hd__decap_3
XFILLER_20_64 VGND VGND VPWR VPWR sky130_fd_sc_hd__decap_3
X_595_ _595_/A _595_/B _595_/C VGND VGND VPWR VPWR _595_/Y sky130_fd_sc_hd__nand3_4
XFILLER_29_95 VGND VGND VPWR VPWR sky130_fd_sc_hd__fill_2
XFILLER_6_88 VGND VGND VPWR VPWR sky130_fd_sc_hd__decap_3
XFILLER_19_182 VGND VGND VPWR VPWR sky130_fd_sc_hd__decap_3
Xrebuffer139 _657_/A VGND VGND VPWR VPWR _555_/A sky130_fd_sc_hd__buf_2
Xrebuffer128 _341_/B VGND VGND VPWR VPWR _324_/A sky130_fd_sc_hd__buf_6
X_380_ _578_/A _380_/B _576_/A _380_/D VGND VGND VPWR VPWR _380_/X sky130_fd_sc_hd__or4_4
XFILLER_25_163 VGND VGND VPWR VPWR sky130_fd_sc_hd__decap_3
XFILLER_15_75 VGND VGND VPWR VPWR sky130_fd_sc_hd__decap_3
XFILLER_15_42 VGND VGND VPWR VPWR sky130_fd_sc_hd__decap_3
XTAP_TAPCELL_ROW_2_78 VGND VPWR sky130_fd_sc_hd__tapvpwrvgnd_1
Xoutput96 _562_/Y VGND VGND VPWR VPWR S[8] sky130_fd_sc_hd__buf_6
Xoutput85 _507_/Y VGND VGND VPWR VPWR S[27] sky130_fd_sc_hd__buf_6
Xoutput74 _402_/Y VGND VGND VPWR VPWR S[17] sky130_fd_sc_hd__buf_6
X_578_ _578_/A _578_/B VGND VGND VPWR VPWR _578_/Y sky130_fd_sc_hd__xnor2_2
X_647_ _655_/A2 _647_/B VGND VGND VPWR VPWR _647_/Y sky130_fd_sc_hd__nand2b_2
XTAP_TAPCELL_ROW_18_136 VGND VPWR sky130_fd_sc_hd__tapvpwrvgnd_1
XFILLER_16_130 VGND VGND VPWR VPWR sky130_fd_sc_hd__decap_3
XFILLER_31_144 VGND VGND VPWR VPWR sky130_fd_sc_hd__fill_2
.ends
