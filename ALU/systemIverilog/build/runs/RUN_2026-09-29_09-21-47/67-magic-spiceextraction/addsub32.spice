* NGSPICE file created from addsub32.ext - technology: sky130A

* Black-box entry subcircuit for sky130_fd_sc_hd__decap_3 abstract view
.subckt sky130_fd_sc_hd__decap_3 VGND VNB VPB VPWR
.ends

* Black-box entry subcircuit for sky130_fd_sc_hd__fill_1 abstract view
.subckt sky130_fd_sc_hd__fill_1 VGND VNB VPB VPWR
.ends

* Black-box entry subcircuit for sky130_fd_sc_hd__o21bai_4 abstract view
.subckt sky130_fd_sc_hd__o21bai_4 A1 A2 B1_N VGND VNB VPB VPWR Y
.ends

* Black-box entry subcircuit for sky130_fd_sc_hd__a21bo_2 abstract view
.subckt sky130_fd_sc_hd__a21bo_2 A1 A2 B1_N VGND VNB VPB VPWR X
.ends

* Black-box entry subcircuit for sky130_fd_sc_hd__tapvpwrvgnd_1 abstract view
.subckt sky130_fd_sc_hd__tapvpwrvgnd_1 VGND VPWR
.ends

* Black-box entry subcircuit for sky130_fd_sc_hd__fill_2 abstract view
.subckt sky130_fd_sc_hd__fill_2 VGND VNB VPB VPWR
.ends

* Black-box entry subcircuit for sky130_fd_sc_hd__nand2b_2 abstract view
.subckt sky130_fd_sc_hd__nand2b_2 A_N B VGND VNB VPB VPWR Y
.ends

* Black-box entry subcircuit for sky130_fd_sc_hd__dlymetal6s4s_1 abstract view
.subckt sky130_fd_sc_hd__dlymetal6s4s_1 A VGND VNB VPB VPWR X
.ends

* Black-box entry subcircuit for sky130_fd_sc_hd__nand3_4 abstract view
.subckt sky130_fd_sc_hd__nand3_4 A B C VGND VNB VPB VPWR Y
.ends

* Black-box entry subcircuit for sky130_fd_sc_hd__o21bai_2 abstract view
.subckt sky130_fd_sc_hd__o21bai_2 A1 A2 B1_N VGND VNB VPB VPWR Y
.ends

* Black-box entry subcircuit for sky130_fd_sc_hd__buf_8 abstract view
.subckt sky130_fd_sc_hd__buf_8 A VGND VNB VPB VPWR X
.ends

* Black-box entry subcircuit for sky130_fd_sc_hd__o21ba_2 abstract view
.subckt sky130_fd_sc_hd__o21ba_2 A1 A2 B1_N VGND VNB VPB VPWR X
.ends

* Black-box entry subcircuit for sky130_fd_sc_hd__and2_4 abstract view
.subckt sky130_fd_sc_hd__and2_4 A B VGND VNB VPB VPWR X
.ends

* Black-box entry subcircuit for sky130_fd_sc_hd__buf_2 abstract view
.subckt sky130_fd_sc_hd__buf_2 A VGND VNB VPB VPWR X
.ends

* Black-box entry subcircuit for sky130_fd_sc_hd__buf_6 abstract view
.subckt sky130_fd_sc_hd__buf_6 A VGND VNB VPB VPWR X
.ends

* Black-box entry subcircuit for sky130_fd_sc_hd__nand2_4 abstract view
.subckt sky130_fd_sc_hd__nand2_4 A B VGND VNB VPB VPWR Y
.ends

* Black-box entry subcircuit for sky130_fd_sc_hd__a21o_2 abstract view
.subckt sky130_fd_sc_hd__a21o_2 A1 A2 B1 VGND VNB VPB VPWR X
.ends

* Black-box entry subcircuit for sky130_fd_sc_hd__nand2_2 abstract view
.subckt sky130_fd_sc_hd__nand2_2 A B VGND VNB VPB VPWR Y
.ends

* Black-box entry subcircuit for sky130_fd_sc_hd__xnor2_2 abstract view
.subckt sky130_fd_sc_hd__xnor2_2 A B VGND VNB VPB VPWR Y
.ends

* Black-box entry subcircuit for sky130_fd_sc_hd__a21oi_4 abstract view
.subckt sky130_fd_sc_hd__a21oi_4 A1 A2 B1 VGND VNB VPB VPWR Y
.ends

* Black-box entry subcircuit for sky130_fd_sc_hd__or3b_4 abstract view
.subckt sky130_fd_sc_hd__or3b_4 A B C_N VGND VNB VPB VPWR X
.ends

* Black-box entry subcircuit for sky130_fd_sc_hd__or3b_2 abstract view
.subckt sky130_fd_sc_hd__or3b_2 A B C_N VGND VNB VPB VPWR X
.ends

* Black-box entry subcircuit for sky130_fd_sc_hd__buf_4 abstract view
.subckt sky130_fd_sc_hd__buf_4 A VGND VNB VPB VPWR X
.ends

* Black-box entry subcircuit for sky130_fd_sc_hd__clkbuf_4 abstract view
.subckt sky130_fd_sc_hd__clkbuf_4 A VGND VNB VPB VPWR X
.ends

* Black-box entry subcircuit for sky130_fd_sc_hd__o211ai_2 abstract view
.subckt sky130_fd_sc_hd__o211ai_2 A1 A2 B1 C1 VGND VNB VPB VPWR Y
.ends

* Black-box entry subcircuit for sky130_fd_sc_hd__o21a_4 abstract view
.subckt sky130_fd_sc_hd__o21a_4 A1 A2 B1 VGND VNB VPB VPWR X
.ends

* Black-box entry subcircuit for sky130_fd_sc_hd__o21ai_2 abstract view
.subckt sky130_fd_sc_hd__o21ai_2 A1 A2 B1 VGND VNB VPB VPWR Y
.ends

* Black-box entry subcircuit for sky130_fd_sc_hd__and2_2 abstract view
.subckt sky130_fd_sc_hd__and2_2 A B VGND VNB VPB VPWR X
.ends

* Black-box entry subcircuit for sky130_fd_sc_hd__a22oi_2 abstract view
.subckt sky130_fd_sc_hd__a22oi_2 A1 A2 B1 B2 VGND VNB VPB VPWR Y
.ends

* Black-box entry subcircuit for sky130_fd_sc_hd__clkbuf_2 abstract view
.subckt sky130_fd_sc_hd__clkbuf_2 A VGND VNB VPB VPWR X
.ends

* Black-box entry subcircuit for sky130_fd_sc_hd__dlymetal6s2s_1 abstract view
.subckt sky130_fd_sc_hd__dlymetal6s2s_1 A VGND VNB VPB VPWR X
.ends

* Black-box entry subcircuit for sky130_fd_sc_hd__a31o_4 abstract view
.subckt sky130_fd_sc_hd__a31o_4 A1 A2 A3 B1 VGND VNB VPB VPWR X
.ends

* Black-box entry subcircuit for sky130_fd_sc_hd__clkdlybuf4s25_1 abstract view
.subckt sky130_fd_sc_hd__clkdlybuf4s25_1 A VGND VNB VPB VPWR X
.ends

* Black-box entry subcircuit for sky130_fd_sc_hd__nand3b_2 abstract view
.subckt sky130_fd_sc_hd__nand3b_2 A_N B C VGND VNB VPB VPWR Y
.ends

* Black-box entry subcircuit for sky130_fd_sc_hd__o2111ai_4 abstract view
.subckt sky130_fd_sc_hd__o2111ai_4 A1 A2 B1 C1 D1 VGND VNB VPB VPWR Y
.ends

* Black-box entry subcircuit for sky130_fd_sc_hd__dlygate4sd1_1 abstract view
.subckt sky130_fd_sc_hd__dlygate4sd1_1 A VGND VNB VPB VPWR X
.ends

* Black-box entry subcircuit for sky130_fd_sc_hd__nor2_2 abstract view
.subckt sky130_fd_sc_hd__nor2_2 A B VGND VNB VPB VPWR Y
.ends

* Black-box entry subcircuit for sky130_fd_sc_hd__o221ai_4 abstract view
.subckt sky130_fd_sc_hd__o221ai_4 A1 A2 B1 B2 C1 VGND VNB VPB VPWR Y
.ends

* Black-box entry subcircuit for sky130_fd_sc_hd__a22o_4 abstract view
.subckt sky130_fd_sc_hd__a22o_4 A1 A2 B1 B2 VGND VNB VPB VPWR X
.ends

* Black-box entry subcircuit for sky130_fd_sc_hd__nor2b_2 abstract view
.subckt sky130_fd_sc_hd__nor2b_2 A B_N VGND VNB VPB VPWR Y
.ends

* Black-box entry subcircuit for sky130_fd_sc_hd__o22a_4 abstract view
.subckt sky130_fd_sc_hd__o22a_4 A1 A2 B1 B2 VGND VNB VPB VPWR X
.ends

* Black-box entry subcircuit for sky130_fd_sc_hd__nor2_4 abstract view
.subckt sky130_fd_sc_hd__nor2_4 A B VGND VNB VPB VPWR Y
.ends

* Black-box entry subcircuit for sky130_fd_sc_hd__o211a_2 abstract view
.subckt sky130_fd_sc_hd__o211a_2 A1 A2 B1 C1 VGND VNB VPB VPWR X
.ends

* Black-box entry subcircuit for sky130_fd_sc_hd__xor2_2 abstract view
.subckt sky130_fd_sc_hd__xor2_2 A B VGND VNB VPB VPWR X
.ends

* Black-box entry subcircuit for sky130_fd_sc_hd__o2bb2ai_2 abstract view
.subckt sky130_fd_sc_hd__o2bb2ai_2 A1_N A2_N B1 B2 VGND VNB VPB VPWR Y
.ends

* Black-box entry subcircuit for sky130_fd_sc_hd__nand4_4 abstract view
.subckt sky130_fd_sc_hd__nand4_4 A B C D VGND VNB VPB VPWR Y
.ends

* Black-box entry subcircuit for sky130_fd_sc_hd__o21a_2 abstract view
.subckt sky130_fd_sc_hd__o21a_2 A1 A2 B1 VGND VNB VPB VPWR X
.ends

* Black-box entry subcircuit for sky130_fd_sc_hd__inv_2 abstract view
.subckt sky130_fd_sc_hd__inv_2 A VGND VNB VPB VPWR Y
.ends

* Black-box entry subcircuit for sky130_fd_sc_hd__nand3_2 abstract view
.subckt sky130_fd_sc_hd__nand3_2 A B C VGND VNB VPB VPWR Y
.ends

* Black-box entry subcircuit for sky130_fd_sc_hd__o22a_2 abstract view
.subckt sky130_fd_sc_hd__o22a_2 A1 A2 B1 B2 VGND VNB VPB VPWR X
.ends

* Black-box entry subcircuit for sky130_fd_sc_hd__nand4_2 abstract view
.subckt sky130_fd_sc_hd__nand4_2 A B C D VGND VNB VPB VPWR Y
.ends

* Black-box entry subcircuit for sky130_fd_sc_hd__a21boi_2 abstract view
.subckt sky130_fd_sc_hd__a21boi_2 A1 A2 B1_N VGND VNB VPB VPWR Y
.ends

* Black-box entry subcircuit for sky130_fd_sc_hd__a21oi_2 abstract view
.subckt sky130_fd_sc_hd__a21oi_2 A1 A2 B1 VGND VNB VPB VPWR Y
.ends

* Black-box entry subcircuit for sky130_fd_sc_hd__o21ai_4 abstract view
.subckt sky130_fd_sc_hd__o21ai_4 A1 A2 B1 VGND VNB VPB VPWR Y
.ends

* Black-box entry subcircuit for sky130_fd_sc_hd__nand3b_4 abstract view
.subckt sky130_fd_sc_hd__nand3b_4 A_N B C VGND VNB VPB VPWR Y
.ends

* Black-box entry subcircuit for sky130_fd_sc_hd__nand2b_4 abstract view
.subckt sky130_fd_sc_hd__nand2b_4 A_N B VGND VNB VPB VPWR Y
.ends

* Black-box entry subcircuit for sky130_fd_sc_hd__nor4_4 abstract view
.subckt sky130_fd_sc_hd__nor4_4 A B C D VGND VNB VPB VPWR Y
.ends

* Black-box entry subcircuit for sky130_fd_sc_hd__a31oi_2 abstract view
.subckt sky130_fd_sc_hd__a31oi_2 A1 A2 A3 B1 VGND VNB VPB VPWR Y
.ends

* Black-box entry subcircuit for sky130_fd_sc_hd__nand4b_2 abstract view
.subckt sky130_fd_sc_hd__nand4b_2 A_N B C D VGND VNB VPB VPWR Y
.ends

* Black-box entry subcircuit for sky130_fd_sc_hd__or2_4 abstract view
.subckt sky130_fd_sc_hd__or2_4 A B VGND VNB VPB VPWR X
.ends

* Black-box entry subcircuit for sky130_fd_sc_hd__a211o_2 abstract view
.subckt sky130_fd_sc_hd__a211o_2 A1 A2 B1 C1 VGND VNB VPB VPWR X
.ends

* Black-box entry subcircuit for sky130_fd_sc_hd__o2111ai_2 abstract view
.subckt sky130_fd_sc_hd__o2111ai_2 A1 A2 B1 C1 D1 VGND VNB VPB VPWR Y
.ends

* Black-box entry subcircuit for sky130_fd_sc_hd__nand4b_4 abstract view
.subckt sky130_fd_sc_hd__nand4b_4 A_N B C D VGND VNB VPB VPWR Y
.ends

* Black-box entry subcircuit for sky130_fd_sc_hd__a22oi_4 abstract view
.subckt sky130_fd_sc_hd__a22oi_4 A1 A2 B1 B2 VGND VNB VPB VPWR Y
.ends

* Black-box entry subcircuit for sky130_fd_sc_hd__a41o_2 abstract view
.subckt sky130_fd_sc_hd__a41o_2 A1 A2 A3 A4 B1 VGND VNB VPB VPWR X
.ends

* Black-box entry subcircuit for sky130_fd_sc_hd__a31oi_4 abstract view
.subckt sky130_fd_sc_hd__a31oi_4 A1 A2 A3 B1 VGND VNB VPB VPWR Y
.ends

* Black-box entry subcircuit for sky130_fd_sc_hd__and4_4 abstract view
.subckt sky130_fd_sc_hd__and4_4 A B C D VGND VNB VPB VPWR X
.ends

* Black-box entry subcircuit for sky130_fd_sc_hd__and3_2 abstract view
.subckt sky130_fd_sc_hd__and3_2 A B C VGND VNB VPB VPWR X
.ends

* Black-box entry subcircuit for sky130_fd_sc_hd__a211oi_4 abstract view
.subckt sky130_fd_sc_hd__a211oi_4 A1 A2 B1 C1 VGND VNB VPB VPWR Y
.ends

* Black-box entry subcircuit for sky130_fd_sc_hd__a2bb2oi_2 abstract view
.subckt sky130_fd_sc_hd__a2bb2oi_2 A1_N A2_N B1 B2 VGND VNB VPB VPWR Y
.ends

* Black-box entry subcircuit for sky130_fd_sc_hd__o2111a_2 abstract view
.subckt sky130_fd_sc_hd__o2111a_2 A1 A2 B1 C1 D1 VGND VNB VPB VPWR X
.ends

* Black-box entry subcircuit for sky130_fd_sc_hd__o31a_2 abstract view
.subckt sky130_fd_sc_hd__o31a_2 A1 A2 A3 B1 VGND VNB VPB VPWR X
.ends

* Black-box entry subcircuit for sky130_fd_sc_hd__and4_2 abstract view
.subckt sky130_fd_sc_hd__and4_2 A B C D VGND VNB VPB VPWR X
.ends

* Black-box entry subcircuit for sky130_fd_sc_hd__o22ai_4 abstract view
.subckt sky130_fd_sc_hd__o22ai_4 A1 A2 B1 B2 VGND VNB VPB VPWR Y
.ends

* Black-box entry subcircuit for sky130_fd_sc_hd__buf_12 abstract view
.subckt sky130_fd_sc_hd__buf_12 A VGND VNB VPB VPWR X
.ends

* Black-box entry subcircuit for sky130_fd_sc_hd__nor2_8 abstract view
.subckt sky130_fd_sc_hd__nor2_8 A B VGND VNB VPB VPWR Y
.ends

* Black-box entry subcircuit for sky130_fd_sc_hd__nor3b_2 abstract view
.subckt sky130_fd_sc_hd__nor3b_2 A B C_N VGND VNB VPB VPWR Y
.ends

* Black-box entry subcircuit for sky130_fd_sc_hd__inv_8 abstract view
.subckt sky130_fd_sc_hd__inv_8 A VGND VNB VPB VPWR Y
.ends

* Black-box entry subcircuit for sky130_fd_sc_hd__o2bb2ai_4 abstract view
.subckt sky130_fd_sc_hd__o2bb2ai_4 A1_N A2_N B1 B2 VGND VNB VPB VPWR Y
.ends

* Black-box entry subcircuit for sky130_fd_sc_hd__a22o_2 abstract view
.subckt sky130_fd_sc_hd__a22o_2 A1 A2 B1 B2 VGND VNB VPB VPWR X
.ends

* Black-box entry subcircuit for sky130_fd_sc_hd__and2b_4 abstract view
.subckt sky130_fd_sc_hd__and2b_4 A_N B VGND VNB VPB VPWR X
.ends

* Black-box entry subcircuit for sky130_fd_sc_hd__a211o_4 abstract view
.subckt sky130_fd_sc_hd__a211o_4 A1 A2 B1 C1 VGND VNB VPB VPWR X
.ends

* Black-box entry subcircuit for sky130_fd_sc_hd__mux2_1 abstract view
.subckt sky130_fd_sc_hd__mux2_1 A0 A1 S VGND VNB VPB VPWR X
.ends

* Black-box entry subcircuit for sky130_fd_sc_hd__o2bb2a_2 abstract view
.subckt sky130_fd_sc_hd__o2bb2a_2 A1_N A2_N B1 B2 VGND VNB VPB VPWR X
.ends

* Black-box entry subcircuit for sky130_fd_sc_hd__or2_2 abstract view
.subckt sky130_fd_sc_hd__or2_2 A B VGND VNB VPB VPWR X
.ends

* Black-box entry subcircuit for sky130_fd_sc_hd__and3b_2 abstract view
.subckt sky130_fd_sc_hd__and3b_2 A_N B C VGND VNB VPB VPWR X
.ends

* Black-box entry subcircuit for sky130_fd_sc_hd__xor2_4 abstract view
.subckt sky130_fd_sc_hd__xor2_4 A B VGND VNB VPB VPWR X
.ends

* Black-box entry subcircuit for sky130_fd_sc_hd__a21o_4 abstract view
.subckt sky130_fd_sc_hd__a21o_4 A1 A2 B1 VGND VNB VPB VPWR X
.ends

* Black-box entry subcircuit for sky130_fd_sc_hd__o22ai_2 abstract view
.subckt sky130_fd_sc_hd__o22ai_2 A1 A2 B1 B2 VGND VNB VPB VPWR Y
.ends

.subckt addsub32 A[0] A[10] A[11] A[12] A[13] A[14] A[15] A[16] A[17] A[18] A[19]
+ A[1] A[20] A[21] A[22] A[23] A[24] A[25] A[26] A[27] A[28] A[29] A[2] A[30] A[31]
+ A[3] A[4] A[5] A[6] A[7] A[8] A[9] B[0] B[10] B[11] B[12] B[13] B[14] B[15] B[16]
+ B[17] B[18] B[19] B[1] B[20] B[21] B[22] B[23] B[24] B[25] B[26] B[27] B[28] B[29]
+ B[2] B[30] B[31] B[3] B[4] B[5] B[6] B[7] B[8] B[9] S[0] S[10] S[11] S[12] S[13]
+ S[14] S[15] S[16] S[17] S[18] S[19] S[1] S[20] S[21] S[22] S[23] S[24] S[25] S[26]
+ S[27] S[28] S[29] S[2] S[30] S[31] S[3] S[4] S[5] S[6] S[7] S[8] S[9] VGND VPWR
+ carryOut sub
XFILLER_22_177 VGND VGND VPWR VPWR sky130_fd_sc_hd__decap_3
XFILLER_22_144 VGND VGND VPWR VPWR sky130_fd_sc_hd__decap_3
XFILLER_13_111 VGND VGND VPWR VPWR sky130_fd_sc_hd__fill_1
XFILLER_13_122 VGND VGND VPWR VPWR sky130_fd_sc_hd__decap_3
X_501_ _498_/Y _499_/X _502_/B1 VGND VGND VPWR VPWR _501_/Y sky130_fd_sc_hd__o21bai_4
X_432_ _659_/A _425_/B _659_/B VGND VGND VPWR VPWR _433_/B sky130_fd_sc_hd__a21bo_2
XTAP_TAPCELL_ROW_15_128 VGND VPWR sky130_fd_sc_hd__tapvpwrvgnd_1
XFILLER_26_85 VGND VGND VPWR VPWR sky130_fd_sc_hd__decap_3
XFILLER_13_166 VGND VGND VPWR VPWR sky130_fd_sc_hd__fill_2
XFILLER_13_188 VGND VGND VPWR VPWR sky130_fd_sc_hd__fill_1
X_363_ _362_/B _363_/B VGND VGND VPWR VPWR _367_/C sky130_fd_sc_hd__nand2b_2
XFILLER_9_159 VGND VGND VPWR VPWR sky130_fd_sc_hd__decap_3
Xfanout116 input65/X VGND VGND VPWR VPWR _488_/A sky130_fd_sc_hd__dlymetal6s4s_1
XFILLER_10_114 VGND VGND VPWR VPWR sky130_fd_sc_hd__fill_1
XFILLER_10_125 VGND VGND VPWR VPWR sky130_fd_sc_hd__decap_3
XFILLER_10_147 VGND VGND VPWR VPWR sky130_fd_sc_hd__fill_2
XFILLER_12_76 VGND VGND VPWR VPWR sky130_fd_sc_hd__decap_3
X_415_ _415_/A _640_/B _640_/D VGND VGND VPWR VPWR _415_/Y sky130_fd_sc_hd__nand3_4
XFILLER_5_173 VGND VGND VPWR VPWR sky130_fd_sc_hd__fill_2
XFILLER_5_162 VGND VGND VPWR VPWR sky130_fd_sc_hd__fill_1
XFILLER_23_86 VGND VGND VPWR VPWR sky130_fd_sc_hd__decap_3
XFILLER_23_53 VGND VGND VPWR VPWR sky130_fd_sc_hd__decap_3
XFILLER_0_24 VGND VGND VPWR VPWR sky130_fd_sc_hd__decap_3
XFILLER_0_57 VGND VGND VPWR VPWR sky130_fd_sc_hd__fill_2
XFILLER_9_11 VGND VGND VPWR VPWR sky130_fd_sc_hd__fill_2
XFILLER_12_209 VGND VGND VPWR VPWR sky130_fd_sc_hd__fill_2
X_680_ _665_/A _665_/B input6/X VGND VGND VPWR VPWR _680_/Y sky130_fd_sc_hd__o21bai_2
XFILLER_18_97 VGND VGND VPWR VPWR sky130_fd_sc_hd__decap_3
Xload_slew105 _400_/A VGND VGND VPWR VPWR _370_/A sky130_fd_sc_hd__buf_8
XFILLER_29_128 VGND VGND VPWR VPWR sky130_fd_sc_hd__decap_3
XFILLER_29_41 VGND VGND VPWR VPWR sky130_fd_sc_hd__decap_3
X_594_ _593_/A _593_/B input24/X VGND VGND VPWR VPWR _613_/A sky130_fd_sc_hd__o21ba_2
X_663_ _664_/A _664_/B VGND VGND VPWR VPWR _665_/A sky130_fd_sc_hd__and2_4
XFILLER_28_194 VGND VGND VPWR VPWR sky130_fd_sc_hd__fill_2
XFILLER_28_172 VGND VGND VPWR VPWR sky130_fd_sc_hd__decap_3
XFILLER_26_109 VGND VGND VPWR VPWR sky130_fd_sc_hd__decap_3
XFILLER_19_172 VGND VGND VPWR VPWR sky130_fd_sc_hd__decap_3
Xrebuffer129 _364_/Y VGND VGND VPWR VPWR _626_/A2 sky130_fd_sc_hd__buf_2
XFILLER_1_208 VGND VGND VPWR VPWR sky130_fd_sc_hd__decap_3
XFILLER_25_175 VGND VGND VPWR VPWR sky130_fd_sc_hd__decap_3
XFILLER_25_153 VGND VGND VPWR VPWR sky130_fd_sc_hd__decap_3
XFILLER_25_142 VGND VGND VPWR VPWR sky130_fd_sc_hd__fill_2
XFILLER_15_54 VGND VGND VPWR VPWR sky130_fd_sc_hd__fill_2
XFILLER_15_76 VGND VGND VPWR VPWR sky130_fd_sc_hd__decap_3
Xoutput75 _445_/X VGND VGND VPWR VPWR S[18] sky130_fd_sc_hd__buf_6
X_715_ _715_/A _715_/B VGND VGND VPWR VPWR _716_/B sky130_fd_sc_hd__nand2_4
Xoutput97 _635_/Y VGND VGND VPWR VPWR S[9] sky130_fd_sc_hd__dlymetal6s4s_1
Xoutput86 _581_/X VGND VGND VPWR VPWR S[28] sky130_fd_sc_hd__buf_6
XFILLER_16_153 VGND VGND VPWR VPWR sky130_fd_sc_hd__fill_2
XFILLER_16_175 VGND VGND VPWR VPWR sky130_fd_sc_hd__decap_3
X_577_ _577_/A _577_/B VGND VGND VPWR VPWR _605_/A sky130_fd_sc_hd__nand2_4
X_646_ _691_/X _641_/A _679_/Y VGND VGND VPWR VPWR _648_/D sky130_fd_sc_hd__a21o_2
XFILLER_31_101 VGND VGND VPWR VPWR sky130_fd_sc_hd__decap_3
XFILLER_22_112 VGND VGND VPWR VPWR sky130_fd_sc_hd__decap_3
XFILLER_22_101 VGND VGND VPWR VPWR sky130_fd_sc_hd__fill_2
X_500_ _498_/Y _499_/X _502_/B1 VGND VGND VPWR VPWR _500_/X sky130_fd_sc_hd__o21ba_2
XFILLER_13_134 VGND VGND VPWR VPWR sky130_fd_sc_hd__decap_3
X_431_ _442_/B _443_/A VGND VGND VPWR VPWR _464_/B sky130_fd_sc_hd__nand2_2
X_362_ _727_/A _362_/B VGND VGND VPWR VPWR _367_/B sky130_fd_sc_hd__nand2_2
XTAP_TAPCELL_ROW_15_129 VGND VPWR sky130_fd_sc_hd__tapvpwrvgnd_1
XFILLER_9_116 VGND VGND VPWR VPWR sky130_fd_sc_hd__decap_3
XFILLER_26_97 VGND VGND VPWR VPWR sky130_fd_sc_hd__decap_3
XFILLER_26_75 VGND VGND VPWR VPWR sky130_fd_sc_hd__decap_3
XFILLER_3_57 VGND VGND VPWR VPWR sky130_fd_sc_hd__decap_3
X_629_ _629_/A _629_/B VGND VGND VPWR VPWR _629_/Y sky130_fd_sc_hd__xnor2_2
XFILLER_8_171 VGND VGND VPWR VPWR sky130_fd_sc_hd__decap_3
Xfanout106 input65/X VGND VGND VPWR VPWR _616_/A0 sky130_fd_sc_hd__buf_8
XFILLER_10_137 VGND VGND VPWR VPWR sky130_fd_sc_hd__decap_3
XFILLER_10_159 VGND VGND VPWR VPWR sky130_fd_sc_hd__decap_3
X_414_ _723_/X _412_/Y _413_/X VGND VGND VPWR VPWR _415_/A sky130_fd_sc_hd__a21oi_4
XFILLER_5_141 VGND VGND VPWR VPWR sky130_fd_sc_hd__decap_3
XPHY_EDGE_ROW_12_Right_12 VGND VGND VPWR VPWR sky130_fd_sc_hd__decap_3
XPHY_EDGE_ROW_21_Right_21 VGND VGND VPWR VPWR sky130_fd_sc_hd__decap_3
XPHY_EDGE_ROW_30_Right_30 VGND VGND VPWR VPWR sky130_fd_sc_hd__decap_3
XFILLER_23_98 VGND VGND VPWR VPWR sky130_fd_sc_hd__decap_3
XFILLER_2_144 VGND VGND VPWR VPWR sky130_fd_sc_hd__decap_3
XFILLER_9_89 VGND VGND VPWR VPWR sky130_fd_sc_hd__decap_3
XFILLER_34_75 VGND VGND VPWR VPWR sky130_fd_sc_hd__fill_1
Xload_slew117 _488_/A VGND VGND VPWR VPWR _546_/A sky130_fd_sc_hd__buf_6
XPHY_EDGE_ROW_28_Left_64 VGND VGND VPWR VPWR sky130_fd_sc_hd__decap_3
XPHY_EDGE_ROW_12_Left_48 VGND VGND VPWR VPWR sky130_fd_sc_hd__decap_3
XFILLER_20_88 VGND VGND VPWR VPWR sky130_fd_sc_hd__decap_3
XFILLER_20_66 VGND VGND VPWR VPWR sky130_fd_sc_hd__decap_3
XFILLER_20_55 VGND VGND VPWR VPWR sky130_fd_sc_hd__decap_3
X_662_ _662_/A _662_/B input7/X VGND VGND VPWR VPWR _692_/C sky130_fd_sc_hd__or3b_4
XFILLER_29_53 VGND VGND VPWR VPWR sky130_fd_sc_hd__decap_3
XFILLER_29_20 VGND VGND VPWR VPWR sky130_fd_sc_hd__decap_3
X_593_ _593_/A _593_/B input24/X VGND VGND VPWR VPWR _605_/B sky130_fd_sc_hd__or3b_2
XFILLER_19_184 VGND VGND VPWR VPWR sky130_fd_sc_hd__decap_3
XFILLER_34_176 VGND VGND VPWR VPWR sky130_fd_sc_hd__decap_3
XPHY_EDGE_ROW_6_Right_6 VGND VGND VPWR VPWR sky130_fd_sc_hd__decap_3
XFILLER_15_33 VGND VGND VPWR VPWR sky130_fd_sc_hd__decap_3
XFILLER_25_165 VGND VGND VPWR VPWR sky130_fd_sc_hd__decap_3
XFILLER_15_88 VGND VGND VPWR VPWR sky130_fd_sc_hd__decap_3
Xoutput98 _651_/Y VGND VGND VPWR VPWR carryOut sky130_fd_sc_hd__buf_4
Xoutput87 _590_/Y VGND VGND VPWR VPWR S[29] sky130_fd_sc_hd__buf_6
Xoutput76 _457_/Y VGND VGND VPWR VPWR S[19] sky130_fd_sc_hd__clkbuf_4
X_645_ _689_/Y _641_/Y _645_/B1 _677_/Y VGND VGND VPWR VPWR _647_/B sky130_fd_sc_hd__o211ai_2
X_714_ _712_/A _712_/B input2/X VGND VGND VPWR VPWR _715_/A sky130_fd_sc_hd__o21a_4
XTAP_TAPCELL_ROW_18_138 VGND VPWR sky130_fd_sc_hd__tapvpwrvgnd_1
X_576_ _573_/B _517_/Y _572_/X VGND VGND VPWR VPWR _576_/Y sky130_fd_sc_hd__o21ai_2
XFILLER_22_135 VGND VGND VPWR VPWR sky130_fd_sc_hd__decap_3
XPHY_EDGE_ROW_15_Left_51 VGND VGND VPWR VPWR sky130_fd_sc_hd__decap_3
XFILLER_13_102 VGND VGND VPWR VPWR sky130_fd_sc_hd__fill_2
XFILLER_13_113 VGND VGND VPWR VPWR sky130_fd_sc_hd__decap_3
XFILLER_13_157 VGND VGND VPWR VPWR sky130_fd_sc_hd__decap_3
XFILLER_13_179 VGND VGND VPWR VPWR sky130_fd_sc_hd__decap_3
X_430_ _426_/Y _427_/X _429_/C VGND VGND VPWR VPWR _443_/A sky130_fd_sc_hd__o21bai_4
X_361_ _370_/A _362_/B VGND VGND VPWR VPWR _361_/X sky130_fd_sc_hd__and2_2
XFILLER_26_65 VGND VGND VPWR VPWR sky130_fd_sc_hd__decap_3
X_628_ _358_/B _357_/Y _627_/B _356_/Y VGND VGND VPWR VPWR _629_/B sky130_fd_sc_hd__a22oi_2
X_559_ _520_/Y _559_/A2 _558_/X VGND VGND VPWR VPWR _559_/Y sky130_fd_sc_hd__a21oi_4
XFILLER_8_150 VGND VGND VPWR VPWR sky130_fd_sc_hd__decap_3
Xfanout107 input65/X VGND VGND VPWR VPWR _655_/B sky130_fd_sc_hd__clkbuf_2
Xfanout118 input65/X VGND VGND VPWR VPWR _499_/A sky130_fd_sc_hd__dlymetal6s2s_1
XFILLER_8_183 VGND VGND VPWR VPWR sky130_fd_sc_hd__decap_3
XFILLER_10_105 VGND VGND VPWR VPWR sky130_fd_sc_hd__decap_3
XFILLER_12_56 VGND VGND VPWR VPWR sky130_fd_sc_hd__decap_3
XPHY_EDGE_ROW_0_Left_36 VGND VGND VPWR VPWR sky130_fd_sc_hd__decap_3
X_413_ _715_/B _721_/Y _715_/A _719_/Y VGND VGND VPWR VPWR _413_/X sky130_fd_sc_hd__a31o_4
XFILLER_5_186 VGND VGND VPWR VPWR sky130_fd_sc_hd__fill_2
XFILLER_5_153 VGND VGND VPWR VPWR sky130_fd_sc_hd__decap_3
XFILLER_23_77 VGND VGND VPWR VPWR sky130_fd_sc_hd__decap_3
XFILLER_23_44 VGND VGND VPWR VPWR sky130_fd_sc_hd__decap_3
XFILLER_3_3 VGND VGND VPWR VPWR sky130_fd_sc_hd__fill_1
XFILLER_2_112 VGND VGND VPWR VPWR sky130_fd_sc_hd__decap_3
XFILLER_0_15 VGND VGND VPWR VPWR sky130_fd_sc_hd__decap_3
XFILLER_9_35 VGND VGND VPWR VPWR sky130_fd_sc_hd__fill_2
XFILLER_9_57 VGND VGND VPWR VPWR sky130_fd_sc_hd__fill_2
XFILLER_20_200 VGND VGND VPWR VPWR sky130_fd_sc_hd__fill_2
XFILLER_18_88 VGND VGND VPWR VPWR sky130_fd_sc_hd__decap_3
XFILLER_29_119 VGND VGND VPWR VPWR sky130_fd_sc_hd__decap_3
XFILLER_20_78 VGND VGND VPWR VPWR sky130_fd_sc_hd__decap_3
X_592_ _655_/B _592_/B VGND VGND VPWR VPWR _593_/B sky130_fd_sc_hd__and2_2
X_661_ _664_/A _661_/B VGND VGND VPWR VPWR _662_/B sky130_fd_sc_hd__and2_4
X_730_ _381_/A _728_/B _730_/B1 VGND VGND VPWR VPWR _730_/Y sky130_fd_sc_hd__o21ai_2
XFILLER_29_32 VGND VGND VPWR VPWR sky130_fd_sc_hd__decap_3
XFILLER_28_152 VGND VGND VPWR VPWR sky130_fd_sc_hd__fill_2
XFILLER_34_144 VGND VGND VPWR VPWR sky130_fd_sc_hd__fill_2
XFILLER_19_163 VGND VGND VPWR VPWR sky130_fd_sc_hd__decap_3
XFILLER_19_130 VGND VGND VPWR VPWR sky130_fd_sc_hd__decap_3
XFILLER_15_45 VGND VGND VPWR VPWR sky130_fd_sc_hd__decap_3
XFILLER_25_133 VGND VGND VPWR VPWR sky130_fd_sc_hd__decap_3
XFILLER_25_111 VGND VGND VPWR VPWR sky130_fd_sc_hd__fill_1
XFILLER_31_55 VGND VGND VPWR VPWR sky130_fd_sc_hd__fill_1
Xoutput88 _620_/X VGND VGND VPWR VPWR S[2] sky130_fd_sc_hd__buf_4
Xoutput77 _617_/Y VGND VGND VPWR VPWR S[1] sky130_fd_sc_hd__buf_6
Xoutput66 _615_/X VGND VGND VPWR VPWR S[0] sky130_fd_sc_hd__clkdlybuf4s25_1
XFILLER_16_100 VGND VGND VPWR VPWR sky130_fd_sc_hd__decap_3
XFILLER_16_144 VGND VGND VPWR VPWR sky130_fd_sc_hd__decap_3
X_575_ _517_/Y _573_/B _572_/X VGND VGND VPWR VPWR _577_/B sky130_fd_sc_hd__o21a_4
X_644_ _689_/Y _644_/B VGND VGND VPWR VPWR _644_/Y sky130_fd_sc_hd__xnor2_2
X_713_ input2/X _713_/B _713_/C VGND VGND VPWR VPWR _716_/A sky130_fd_sc_hd__nand3b_2
XTAP_TAPCELL_ROW_18_139 VGND VPWR sky130_fd_sc_hd__tapvpwrvgnd_1
XFILLER_22_147 VGND VGND VPWR VPWR sky130_fd_sc_hd__fill_1
XTAP_TAPCELL_ROW_9_107 VGND VPWR sky130_fd_sc_hd__tapvpwrvgnd_1
XFILLER_13_125 VGND VGND VPWR VPWR sky130_fd_sc_hd__decap_3
X_360_ _728_/X _730_/Y _356_/Y _358_/Y _729_/Y VGND VGND VPWR VPWR _378_/A sky130_fd_sc_hd__o2111ai_4
XFILLER_26_88 VGND VGND VPWR VPWR sky130_fd_sc_hd__decap_3
X_558_ _558_/A _558_/B _571_/B VGND VGND VPWR VPWR _558_/X sky130_fd_sc_hd__or3b_4
X_627_ _627_/A _627_/B VGND VGND VPWR VPWR _627_/Y sky130_fd_sc_hd__xnor2_2
XFILLER_12_180 VGND VGND VPWR VPWR sky130_fd_sc_hd__decap_3
X_489_ _499_/A _490_/B VGND VGND VPWR VPWR _489_/X sky130_fd_sc_hd__and2_4
XFILLER_8_162 VGND VGND VPWR VPWR sky130_fd_sc_hd__decap_3
Xfanout119 input65/X VGND VGND VPWR VPWR _473_/A sky130_fd_sc_hd__dlygate4sd1_1
XFILLER_10_128 VGND VGND VPWR VPWR sky130_fd_sc_hd__fill_2
XFILLER_12_79 VGND VGND VPWR VPWR sky130_fd_sc_hd__decap_3
XTAP_TAPCELL_ROW_20_145 VGND VPWR sky130_fd_sc_hd__tapvpwrvgnd_1
X_412_ _709_/C _696_/X _709_/A VGND VGND VPWR VPWR _412_/Y sky130_fd_sc_hd__o21ai_2
XFILLER_23_89 VGND VGND VPWR VPWR sky130_fd_sc_hd__decap_3
XFILLER_0_27 VGND VGND VPWR VPWR sky130_fd_sc_hd__fill_1
Xload_slew108 _655_/B VGND VGND VPWR VPWR _436_/A sky130_fd_sc_hd__buf_4
XFILLER_20_24 VGND VGND VPWR VPWR sky130_fd_sc_hd__decap_3
XFILLER_29_44 VGND VGND VPWR VPWR sky130_fd_sc_hd__decap_3
XFILLER_20_46 VGND VGND VPWR VPWR sky130_fd_sc_hd__decap_3
X_591_ _655_/B _592_/B VGND VGND VPWR VPWR _593_/A sky130_fd_sc_hd__nor2_2
X_660_ _664_/A _661_/B VGND VGND VPWR VPWR _662_/A sky130_fd_sc_hd__nor2_2
XFILLER_28_197 VGND VGND VPWR VPWR sky130_fd_sc_hd__decap_3
XFILLER_28_175 VGND VGND VPWR VPWR sky130_fd_sc_hd__decap_3
XFILLER_34_189 VGND VGND VPWR VPWR sky130_fd_sc_hd__decap_3
XFILLER_34_101 VGND VGND VPWR VPWR sky130_fd_sc_hd__decap_3
XFILLER_15_57 VGND VGND VPWR VPWR sky130_fd_sc_hd__decap_3
XFILLER_15_79 VGND VGND VPWR VPWR sky130_fd_sc_hd__decap_3
XFILLER_25_178 VGND VGND VPWR VPWR sky130_fd_sc_hd__decap_3
XFILLER_25_156 VGND VGND VPWR VPWR sky130_fd_sc_hd__decap_3
X_712_ _712_/A _712_/B VGND VGND VPWR VPWR _715_/B sky130_fd_sc_hd__nand2_2
Xoutput89 _604_/Y VGND VGND VPWR VPWR S[30] sky130_fd_sc_hd__buf_6
Xoutput78 _471_/X VGND VGND VPWR VPWR S[20] sky130_fd_sc_hd__buf_6
Xoutput67 _637_/X VGND VGND VPWR VPWR S[10] sky130_fd_sc_hd__dlymetal6s4s_1
XFILLER_16_112 VGND VGND VPWR VPWR sky130_fd_sc_hd__decap_3
XFILLER_16_178 VGND VGND VPWR VPWR sky130_fd_sc_hd__decap_3
X_574_ _692_/X _685_/Y _422_/Y _415_/Y _573_/Y VGND VGND VPWR VPWR _577_/A sky130_fd_sc_hd__o221ai_4
X_643_ _677_/C _677_/B _641_/A _692_/A VGND VGND VPWR VPWR _644_/B sky130_fd_sc_hd__a22o_4
XFILLER_22_126 VGND VGND VPWR VPWR sky130_fd_sc_hd__decap_3
XFILLER_22_115 VGND VGND VPWR VPWR sky130_fd_sc_hd__decap_3
XTAP_TAPCELL_ROW_9_108 VGND VPWR sky130_fd_sc_hd__tapvpwrvgnd_1
XTAP_TAPCELL_ROW_32_187 VGND VPWR sky130_fd_sc_hd__tapvpwrvgnd_1
XFILLER_30_181 VGND VGND VPWR VPWR sky130_fd_sc_hd__decap_3
XFILLER_26_78 VGND VGND VPWR VPWR sky130_fd_sc_hd__decap_3
XFILLER_26_56 VGND VGND VPWR VPWR sky130_fd_sc_hd__decap_3
XFILLER_26_34 VGND VGND VPWR VPWR sky130_fd_sc_hd__decap_3
XFILLER_13_137 VGND VGND VPWR VPWR sky130_fd_sc_hd__decap_3
XFILLER_9_119 VGND VGND VPWR VPWR sky130_fd_sc_hd__decap_3
XFILLER_21_181 VGND VGND VPWR VPWR sky130_fd_sc_hd__decap_3
XFILLER_3_49 VGND VGND VPWR VPWR sky130_fd_sc_hd__decap_3
X_557_ _557_/A _556_/X VGND VGND VPWR VPWR _571_/C sky130_fd_sc_hd__nor2b_2
X_626_ _361_/X _626_/A2 _625_/B _366_/X VGND VGND VPWR VPWR _627_/B sky130_fd_sc_hd__o22a_4
X_488_ _488_/A _490_/B VGND VGND VPWR VPWR _488_/Y sky130_fd_sc_hd__nor2_4
XFILLER_12_192 VGND VGND VPWR VPWR sky130_fd_sc_hd__decap_3
XFILLER_8_174 VGND VGND VPWR VPWR sky130_fd_sc_hd__decap_3
XFILLER_8_141 VGND VGND VPWR VPWR sky130_fd_sc_hd__decap_3
Xfanout109 input65/X VGND VGND VPWR VPWR _606_/A sky130_fd_sc_hd__dlygate4sd1_1
XTAP_TAPCELL_ROW_20_146 VGND VPWR sky130_fd_sc_hd__tapvpwrvgnd_1
XFILLER_12_47 VGND VGND VPWR VPWR sky130_fd_sc_hd__decap_3
X_411_ _411_/A _725_/Y _411_/C VGND VGND VPWR VPWR _640_/B sky130_fd_sc_hd__nand3_4
XFILLER_5_144 VGND VGND VPWR VPWR sky130_fd_sc_hd__decap_3
XFILLER_5_100 VGND VGND VPWR VPWR sky130_fd_sc_hd__fill_2
X_609_ _613_/A _601_/A _613_/B _605_/B VGND VGND VPWR VPWR _609_/X sky130_fd_sc_hd__o211a_2
XFILLER_2_147 VGND VGND VPWR VPWR sky130_fd_sc_hd__fill_1
XFILLER_2_125 VGND VGND VPWR VPWR sky130_fd_sc_hd__fill_1
XFILLER_9_26 VGND VGND VPWR VPWR sky130_fd_sc_hd__decap_3
XFILLER_1_60 VGND VGND VPWR VPWR sky130_fd_sc_hd__fill_1
XFILLER_20_58 VGND VGND VPWR VPWR sky130_fd_sc_hd__decap_3
XFILLER_29_23 VGND VGND VPWR VPWR sky130_fd_sc_hd__fill_1
XFILLER_20_69 VGND VGND VPWR VPWR sky130_fd_sc_hd__decap_3
X_590_ _568_/Y _588_/Y _589_/Y VGND VGND VPWR VPWR _590_/Y sky130_fd_sc_hd__o21ai_2
XFILLER_28_121 VGND VGND VPWR VPWR sky130_fd_sc_hd__fill_2
XFILLER_10_91 VGND VGND VPWR VPWR sky130_fd_sc_hd__decap_3
XFILLER_6_38 VGND VGND VPWR VPWR sky130_fd_sc_hd__decap_3
XFILLER_34_179 VGND VGND VPWR VPWR sky130_fd_sc_hd__fill_1
XFILLER_19_187 VGND VGND VPWR VPWR sky130_fd_sc_hd__fill_1
XFILLER_15_36 VGND VGND VPWR VPWR sky130_fd_sc_hd__fill_2
XFILLER_31_57 VGND VGND VPWR VPWR sky130_fd_sc_hd__decap_3
X_642_ _692_/A _642_/B VGND VGND VPWR VPWR _642_/X sky130_fd_sc_hd__xor2_2
X_711_ _727_/A _712_/B VGND VGND VPWR VPWR _713_/C sky130_fd_sc_hd__nand2_2
Xoutput79 _482_/Y VGND VGND VPWR VPWR S[21] sky130_fd_sc_hd__buf_8
Xoutput68 _639_/X VGND VGND VPWR VPWR S[11] sky130_fd_sc_hd__clkbuf_2
X_573_ _573_/A _573_/B VGND VGND VPWR VPWR _573_/Y sky130_fd_sc_hd__nor2_4
XPHY_EDGE_ROW_19_Right_19 VGND VGND VPWR VPWR sky130_fd_sc_hd__decap_3
XFILLER_31_149 VGND VGND VPWR VPWR sky130_fd_sc_hd__decap_3
XFILLER_24_190 VGND VGND VPWR VPWR sky130_fd_sc_hd__decap_3
XPHY_EDGE_ROW_28_Right_28 VGND VGND VPWR VPWR sky130_fd_sc_hd__decap_3
XFILLER_21_90 VGND VGND VPWR VPWR sky130_fd_sc_hd__decap_3
XTAP_TAPCELL_ROW_32_188 VGND VPWR sky130_fd_sc_hd__tapvpwrvgnd_1
XFILLER_22_138 VGND VGND VPWR VPWR sky130_fd_sc_hd__fill_2
XTAP_TAPCELL_ROW_9_109 VGND VPWR sky130_fd_sc_hd__tapvpwrvgnd_1
XFILLER_13_116 VGND VGND VPWR VPWR sky130_fd_sc_hd__decap_3
XFILLER_26_68 VGND VGND VPWR VPWR sky130_fd_sc_hd__fill_2
X_625_ _625_/A _625_/B VGND VGND VPWR VPWR _625_/Y sky130_fd_sc_hd__xnor2_2
XFILLER_12_171 VGND VGND VPWR VPWR sky130_fd_sc_hd__decap_3
X_556_ _556_/A _556_/B input20/X VGND VGND VPWR VPWR _556_/X sky130_fd_sc_hd__or3b_2
X_487_ _506_/A _507_/A _474_/X _484_/X VGND VGND VPWR VPWR _496_/A sky130_fd_sc_hd__o2bb2ai_2
XFILLER_8_197 VGND VGND VPWR VPWR sky130_fd_sc_hd__decap_3
XFILLER_8_186 VGND VGND VPWR VPWR sky130_fd_sc_hd__decap_3
XFILLER_8_153 VGND VGND VPWR VPWR sky130_fd_sc_hd__decap_3
XPHY_EDGE_ROW_19_Left_55 VGND VGND VPWR VPWR sky130_fd_sc_hd__decap_3
XFILLER_10_108 VGND VGND VPWR VPWR sky130_fd_sc_hd__decap_3
XFILLER_12_59 VGND VGND VPWR VPWR sky130_fd_sc_hd__decap_3
XTAP_TAPCELL_ROW_20_147 VGND VPWR sky130_fd_sc_hd__tapvpwrvgnd_1
X_410_ _420_/B _725_/Y _410_/C _410_/D VGND VGND VPWR VPWR _640_/D sky130_fd_sc_hd__nand4_4
XTAP_TAPCELL_ROW_11_114 VGND VPWR sky130_fd_sc_hd__tapvpwrvgnd_1
XFILLER_5_156 VGND VGND VPWR VPWR sky130_fd_sc_hd__decap_3
X_608_ _585_/X _597_/B _597_/C _605_/B VGND VGND VPWR VPWR _611_/B sky130_fd_sc_hd__o211a_2
XFILLER_32_200 VGND VGND VPWR VPWR sky130_fd_sc_hd__fill_1
X_539_ _528_/Y _524_/X _558_/B VGND VGND VPWR VPWR _540_/A sky130_fd_sc_hd__o21ai_2
XFILLER_23_47 VGND VGND VPWR VPWR sky130_fd_sc_hd__decap_3
XFILLER_2_115 VGND VGND VPWR VPWR sky130_fd_sc_hd__fill_1
XFILLER_0_18 VGND VGND VPWR VPWR sky130_fd_sc_hd__decap_3
XFILLER_0_29 VGND VGND VPWR VPWR sky130_fd_sc_hd__decap_3
XFILLER_13_91 VGND VGND VPWR VPWR sky130_fd_sc_hd__fill_1
XTAP_TAPCELL_ROW_0_72 VGND VPWR sky130_fd_sc_hd__tapvpwrvgnd_1
XFILLER_18_47 VGND VGND VPWR VPWR sky130_fd_sc_hd__fill_2
XFILLER_34_46 VGND VGND VPWR VPWR sky130_fd_sc_hd__decap_3
XFILLER_1_3 VGND VGND VPWR VPWR sky130_fd_sc_hd__decap_3
XFILLER_34_3 VGND VGND VPWR VPWR sky130_fd_sc_hd__fill_2
XFILLER_29_57 VGND VGND VPWR VPWR sky130_fd_sc_hd__decap_3
XFILLER_29_35 VGND VGND VPWR VPWR sky130_fd_sc_hd__decap_3
XPHY_EDGE_ROW_7_Left_43 VGND VGND VPWR VPWR sky130_fd_sc_hd__decap_3
XFILLER_19_166 VGND VGND VPWR VPWR sky130_fd_sc_hd__fill_2
XFILLER_19_133 VGND VGND VPWR VPWR sky130_fd_sc_hd__decap_3
XFILLER_19_111 VGND VGND VPWR VPWR sky130_fd_sc_hd__fill_1
XFILLER_15_48 VGND VGND VPWR VPWR sky130_fd_sc_hd__decap_3
XFILLER_25_169 VGND VGND VPWR VPWR sky130_fd_sc_hd__decap_3
XFILLER_25_136 VGND VGND VPWR VPWR sky130_fd_sc_hd__decap_3
XFILLER_25_103 VGND VGND VPWR VPWR sky130_fd_sc_hd__decap_3
XFILLER_31_14 VGND VGND VPWR VPWR sky130_fd_sc_hd__fill_2
Xoutput69 _642_/X VGND VGND VPWR VPWR S[12] sky130_fd_sc_hd__buf_6
XPHY_EDGE_ROW_33_Left_69 VGND VGND VPWR VPWR sky130_fd_sc_hd__decap_3
XFILLER_16_103 VGND VGND VPWR VPWR sky130_fd_sc_hd__decap_3
X_572_ _557_/A _560_/Y _556_/X VGND VGND VPWR VPWR _572_/X sky130_fd_sc_hd__o21a_2
X_641_ _641_/A _692_/A VGND VGND VPWR VPWR _641_/Y sky130_fd_sc_hd__nand2_2
X_710_ _712_/B _712_/A VGND VGND VPWR VPWR _713_/B sky130_fd_sc_hd__nand2b_2
XFILLER_16_147 VGND VGND VPWR VPWR sky130_fd_sc_hd__decap_3
XFILLER_16_169 VGND VGND VPWR VPWR sky130_fd_sc_hd__decap_3
XTAP_TAPCELL_ROW_32_189 VGND VPWR sky130_fd_sc_hd__tapvpwrvgnd_1
XFILLER_30_172 VGND VGND VPWR VPWR sky130_fd_sc_hd__decap_3
XFILLER_30_161 VGND VGND VPWR VPWR sky130_fd_sc_hd__fill_2
XFILLER_30_150 VGND VGND VPWR VPWR sky130_fd_sc_hd__fill_1
XFILLER_7_71 VGND VGND VPWR VPWR sky130_fd_sc_hd__fill_1
XFILLER_7_60 VGND VGND VPWR VPWR sky130_fd_sc_hd__fill_2
XFILLER_13_128 VGND VGND VPWR VPWR sky130_fd_sc_hd__decap_3
XTAP_TAPCELL_ROW_23_156 VGND VPWR sky130_fd_sc_hd__tapvpwrvgnd_1
XFILLER_21_172 VGND VGND VPWR VPWR sky130_fd_sc_hd__decap_3
XFILLER_21_161 VGND VGND VPWR VPWR sky130_fd_sc_hd__decap_3
X_555_ _556_/A _556_/B input20/X VGND VGND VPWR VPWR _557_/A sky130_fd_sc_hd__o21ba_2
X_624_ _410_/C _410_/D _420_/A VGND VGND VPWR VPWR _625_/B sky130_fd_sc_hd__a21oi_4
XFILLER_12_183 VGND VGND VPWR VPWR sky130_fd_sc_hd__decap_3
XFILLER_16_91 VGND VGND VPWR VPWR sky130_fd_sc_hd__decap_3
X_486_ _486_/A VGND VGND VPWR VPWR _486_/Y sky130_fd_sc_hd__inv_2
XFILLER_8_165 VGND VGND VPWR VPWR sky130_fd_sc_hd__decap_3
XTAP_TAPCELL_ROW_20_148 VGND VPWR sky130_fd_sc_hd__tapvpwrvgnd_1
XTAP_TAPCELL_ROW_11_115 VGND VPWR sky130_fd_sc_hd__tapvpwrvgnd_1
XFILLER_5_135 VGND VGND VPWR VPWR sky130_fd_sc_hd__decap_3
X_538_ _558_/B _538_/B _538_/C VGND VGND VPWR VPWR _540_/B sky130_fd_sc_hd__nand3b_2
X_607_ _607_/A _607_/B VGND VGND VPWR VPWR _613_/B sky130_fd_sc_hd__xnor2_2
XPHY_EDGE_ROW_20_Left_56 VGND VGND VPWR VPWR sky130_fd_sc_hd__decap_3
X_469_ _467_/Y _468_/Y _466_/B VGND VGND VPWR VPWR _469_/Y sky130_fd_sc_hd__o21ai_2
XFILLER_4_94 VGND VGND VPWR VPWR sky130_fd_sc_hd__decap_3
XFILLER_4_50 VGND VGND VPWR VPWR sky130_fd_sc_hd__decap_3
XFILLER_23_26 VGND VGND VPWR VPWR sky130_fd_sc_hd__fill_2
XTAP_TAPCELL_ROW_0_73 VGND VPWR sky130_fd_sc_hd__tapvpwrvgnd_1
XFILLER_24_80 VGND VGND VPWR VPWR sky130_fd_sc_hd__decap_3
XFILLER_27_3 VGND VGND VPWR VPWR sky130_fd_sc_hd__fill_1
XFILLER_1_95 VGND VGND VPWR VPWR sky130_fd_sc_hd__decap_3
XFILLER_20_49 VGND VGND VPWR VPWR sky130_fd_sc_hd__decap_3
XFILLER_20_27 VGND VGND VPWR VPWR sky130_fd_sc_hd__fill_1
XFILLER_29_47 VGND VGND VPWR VPWR sky130_fd_sc_hd__decap_3
XFILLER_28_178 VGND VGND VPWR VPWR sky130_fd_sc_hd__fill_1
XFILLER_6_29 VGND VGND VPWR VPWR sky130_fd_sc_hd__decap_3
XFILLER_10_71 VGND VGND VPWR VPWR sky130_fd_sc_hd__decap_3
XFILLER_34_126 VGND VGND VPWR VPWR sky130_fd_sc_hd__fill_1
XFILLER_25_159 VGND VGND VPWR VPWR sky130_fd_sc_hd__decap_3
XTAP_TAPCELL_ROW_35_198 VGND VPWR sky130_fd_sc_hd__tapvpwrvgnd_1
XFILLER_31_37 VGND VGND VPWR VPWR sky130_fd_sc_hd__fill_2
XPHY_EDGE_ROW_1_Right_1 VGND VGND VPWR VPWR sky130_fd_sc_hd__decap_3
XFILLER_16_115 VGND VGND VPWR VPWR sky130_fd_sc_hd__decap_3
X_571_ _571_/A _571_/B _571_/C VGND VGND VPWR VPWR _573_/B sky130_fd_sc_hd__nand3_4
X_640_ _640_/A _640_/B _640_/C _640_/D VGND VGND VPWR VPWR _641_/A sky130_fd_sc_hd__nand4_4
XFILLER_24_181 VGND VGND VPWR VPWR sky130_fd_sc_hd__decap_3
XFILLER_21_81 VGND VGND VPWR VPWR sky130_fd_sc_hd__decap_3
XFILLER_22_129 VGND VGND VPWR VPWR sky130_fd_sc_hd__decap_3
XFILLER_22_118 VGND VGND VPWR VPWR sky130_fd_sc_hd__fill_2
XFILLER_15_181 VGND VGND VPWR VPWR sky130_fd_sc_hd__decap_3
XFILLER_30_195 VGND VGND VPWR VPWR sky130_fd_sc_hd__fill_1
XFILLER_30_184 VGND VGND VPWR VPWR sky130_fd_sc_hd__decap_3
XFILLER_26_37 VGND VGND VPWR VPWR sky130_fd_sc_hd__decap_3
XTAP_TAPCELL_ROW_23_157 VGND VPWR sky130_fd_sc_hd__tapvpwrvgnd_1
XFILLER_26_59 VGND VGND VPWR VPWR sky130_fd_sc_hd__decap_3
XFILLER_21_140 VGND VGND VPWR VPWR sky130_fd_sc_hd__decap_3
XFILLER_21_184 VGND VGND VPWR VPWR sky130_fd_sc_hd__decap_3
X_554_ _664_/A _554_/B VGND VGND VPWR VPWR _556_/B sky130_fd_sc_hd__and2_4
X_623_ _621_/Y _623_/B VGND VGND VPWR VPWR _623_/Y sky130_fd_sc_hd__nand2b_2
X_485_ _515_/A _477_/Y _475_/Y VGND VGND VPWR VPWR _486_/A sky130_fd_sc_hd__o21ai_2
XFILLER_12_162 VGND VGND VPWR VPWR sky130_fd_sc_hd__decap_3
XFILLER_12_195 VGND VGND VPWR VPWR sky130_fd_sc_hd__fill_1
XFILLER_16_81 VGND VGND VPWR VPWR sky130_fd_sc_hd__decap_3
XTAP_TAPCELL_ROW_14_124 VGND VPWR sky130_fd_sc_hd__tapvpwrvgnd_1
XFILLER_8_177 VGND VGND VPWR VPWR sky130_fd_sc_hd__decap_3
XFILLER_8_144 VGND VGND VPWR VPWR sky130_fd_sc_hd__decap_3
XFILLER_8_111 VGND VGND VPWR VPWR sky130_fd_sc_hd__decap_3
XFILLER_35_210 VGND VGND VPWR VPWR sky130_fd_sc_hd__fill_1
XFILLER_26_210 VGND VGND VPWR VPWR sky130_fd_sc_hd__fill_1
Xrebuffer230 _565_/A VGND VGND VPWR VPWR _583_/A sky130_fd_sc_hd__buf_4
XTAP_TAPCELL_ROW_11_116 VGND VPWR sky130_fd_sc_hd__tapvpwrvgnd_1
XFILLER_5_147 VGND VGND VPWR VPWR sky130_fd_sc_hd__decap_3
X_537_ _533_/X _535_/Y _534_/X VGND VGND VPWR VPWR _558_/B sky130_fd_sc_hd__o21bai_4
X_606_ _606_/A _606_/B VGND VGND VPWR VPWR _607_/B sky130_fd_sc_hd__xor2_2
X_468_ _438_/C _437_/Y _443_/B _443_/A VGND VGND VPWR VPWR _468_/Y sky130_fd_sc_hd__a22oi_2
XFILLER_27_91 VGND VGND VPWR VPWR sky130_fd_sc_hd__decap_3
X_399_ _400_/A _400_/B VGND VGND VPWR VPWR _399_/X sky130_fd_sc_hd__and2_4
XFILLER_4_62 VGND VGND VPWR VPWR sky130_fd_sc_hd__fill_1
XFILLER_9_29 VGND VGND VPWR VPWR sky130_fd_sc_hd__decap_3
XFILLER_9_18 VGND VGND VPWR VPWR sky130_fd_sc_hd__decap_3
XFILLER_13_60 VGND VGND VPWR VPWR sky130_fd_sc_hd__fill_1
XFILLER_13_71 VGND VGND VPWR VPWR sky130_fd_sc_hd__decap_3
XTAP_TAPCELL_ROW_0_74 VGND VPWR sky130_fd_sc_hd__tapvpwrvgnd_1
XFILLER_18_27 VGND VGND VPWR VPWR sky130_fd_sc_hd__fill_1
XFILLER_34_59 VGND VGND VPWR VPWR sky130_fd_sc_hd__fill_2
XFILLER_34_26 VGND VGND VPWR VPWR sky130_fd_sc_hd__fill_2
XFILLER_1_74 VGND VGND VPWR VPWR sky130_fd_sc_hd__decap_3
XFILLER_10_50 VGND VGND VPWR VPWR sky130_fd_sc_hd__decap_3
XFILLER_10_94 VGND VGND VPWR VPWR sky130_fd_sc_hd__decap_3
XFILLER_19_102 VGND VGND VPWR VPWR sky130_fd_sc_hd__decap_3
XTAP_TAPCELL_ROW_35_199 VGND VPWR sky130_fd_sc_hd__tapvpwrvgnd_1
XFILLER_31_49 VGND VGND VPWR VPWR sky130_fd_sc_hd__decap_3
XFILLER_31_27 VGND VGND VPWR VPWR sky130_fd_sc_hd__fill_1
X_570_ _597_/A _597_/B VGND VGND VPWR VPWR _570_/Y sky130_fd_sc_hd__nand2_2
XTAP_TAPCELL_ROW_26_166 VGND VPWR sky130_fd_sc_hd__tapvpwrvgnd_1
XFILLER_24_193 VGND VGND VPWR VPWR sky130_fd_sc_hd__decap_3
XFILLER_15_160 VGND VGND VPWR VPWR sky130_fd_sc_hd__decap_3
X_699_ _695_/A _695_/B _698_/Y VGND VGND VPWR VPWR _709_/A sky130_fd_sc_hd__o21ai_2
XFILLER_30_130 VGND VGND VPWR VPWR sky130_fd_sc_hd__decap_3
XFILLER_7_84 VGND VGND VPWR VPWR sky130_fd_sc_hd__decap_3
XFILLER_30_141 VGND VGND VPWR VPWR sky130_fd_sc_hd__decap_3
XPHY_EDGE_ROW_15_Right_15 VGND VGND VPWR VPWR sky130_fd_sc_hd__decap_3
XPHY_EDGE_ROW_24_Right_24 VGND VGND VPWR VPWR sky130_fd_sc_hd__decap_3
XFILLER_13_108 VGND VGND VPWR VPWR sky130_fd_sc_hd__decap_3
XFILLER_13_119 VGND VGND VPWR VPWR sky130_fd_sc_hd__decap_3
XTAP_TAPCELL_ROW_23_158 VGND VPWR sky130_fd_sc_hd__tapvpwrvgnd_1
XFILLER_21_152 VGND VGND VPWR VPWR sky130_fd_sc_hd__decap_3
XPHY_EDGE_ROW_33_Right_33 VGND VGND VPWR VPWR sky130_fd_sc_hd__decap_3
X_622_ _622_/A _622_/B _622_/C VGND VGND VPWR VPWR _623_/B sky130_fd_sc_hd__nand3_2
X_553_ _664_/A _554_/B VGND VGND VPWR VPWR _556_/A sky130_fd_sc_hd__nor2_2
X_484_ _476_/Y _473_/X _460_/Y _458_/X VGND VGND VPWR VPWR _484_/X sky130_fd_sc_hd__o22a_2
XTAP_TAPCELL_ROW_14_125 VGND VPWR sky130_fd_sc_hd__tapvpwrvgnd_1
XFILLER_12_141 VGND VGND VPWR VPWR sky130_fd_sc_hd__decap_3
XFILLER_12_174 VGND VGND VPWR VPWR sky130_fd_sc_hd__decap_3
XFILLER_8_156 VGND VGND VPWR VPWR sky130_fd_sc_hd__decap_3
XFILLER_32_81 VGND VGND VPWR VPWR sky130_fd_sc_hd__decap_3
Xrebuffer231 _565_/A VGND VGND VPWR VPWR _394_/A sky130_fd_sc_hd__buf_2
Xrebuffer220 _627_/B VGND VGND VPWR VPWR _630_/B2 sky130_fd_sc_hd__buf_2
XFILLER_5_159 VGND VGND VPWR VPWR sky130_fd_sc_hd__decap_3
X_605_ _605_/A _605_/B _605_/C _605_/D VGND VGND VPWR VPWR _605_/Y sky130_fd_sc_hd__nand4_2
X_536_ _545_/A _533_/B _535_/Y VGND VGND VPWR VPWR _536_/X sky130_fd_sc_hd__a21o_2
X_467_ _452_/A _452_/B _440_/B VGND VGND VPWR VPWR _467_/Y sky130_fd_sc_hd__o21ai_2
X_398_ _395_/X _397_/Y _622_/A VGND VGND VPWR VPWR _620_/A sky130_fd_sc_hd__o21a_2
XFILLER_4_41 VGND VGND VPWR VPWR sky130_fd_sc_hd__decap_3
XFILLER_4_181 VGND VGND VPWR VPWR sky130_fd_sc_hd__decap_3
XFILLER_13_50 VGND VGND VPWR VPWR sky130_fd_sc_hd__decap_3
XTAP_TAPCELL_ROW_0_75 VGND VPWR sky130_fd_sc_hd__tapvpwrvgnd_1
X_519_ _519_/A _519_/B VGND VGND VPWR VPWR _573_/A sky130_fd_sc_hd__nand2_2
XFILLER_34_49 VGND VGND VPWR VPWR sky130_fd_sc_hd__fill_1
XFILLER_20_29 VGND VGND VPWR VPWR sky130_fd_sc_hd__fill_1
XFILLER_29_38 VGND VGND VPWR VPWR sky130_fd_sc_hd__decap_3
XFILLER_19_60 VGND VGND VPWR VPWR sky130_fd_sc_hd__decap_3
XFILLER_19_136 VGND VGND VPWR VPWR sky130_fd_sc_hd__fill_1
XFILLER_19_169 VGND VGND VPWR VPWR sky130_fd_sc_hd__decap_3
XTAP_TAPCELL_ROW_6_96 VGND VPWR sky130_fd_sc_hd__tapvpwrvgnd_1
XFILLER_25_139 VGND VGND VPWR VPWR sky130_fd_sc_hd__decap_3
XFILLER_0_205 VGND VGND VPWR VPWR sky130_fd_sc_hd__decap_3
XFILLER_16_106 VGND VGND VPWR VPWR sky130_fd_sc_hd__decap_3
XTAP_TAPCELL_ROW_26_167 VGND VPWR sky130_fd_sc_hd__tapvpwrvgnd_1
XFILLER_24_161 VGND VGND VPWR VPWR sky130_fd_sc_hd__decap_3
XFILLER_24_150 VGND VGND VPWR VPWR sky130_fd_sc_hd__decap_3
X_698_ _673_/A _695_/B input32/X VGND VGND VPWR VPWR _698_/Y sky130_fd_sc_hd__a21boi_2
XFILLER_22_109 VGND VGND VPWR VPWR sky130_fd_sc_hd__decap_3
XFILLER_7_52 VGND VGND VPWR VPWR sky130_fd_sc_hd__decap_3
XFILLER_7_41 VGND VGND VPWR VPWR sky130_fd_sc_hd__decap_3
XFILLER_30_197 VGND VGND VPWR VPWR sky130_fd_sc_hd__fill_1
XFILLER_30_175 VGND VGND VPWR VPWR sky130_fd_sc_hd__decap_3
XFILLER_21_175 VGND VGND VPWR VPWR sky130_fd_sc_hd__decap_3
XFILLER_21_164 VGND VGND VPWR VPWR sky130_fd_sc_hd__decap_3
XFILLER_21_131 VGND VGND VPWR VPWR sky130_fd_sc_hd__decap_3
X_621_ _622_/A _622_/C _622_/B VGND VGND VPWR VPWR _621_/Y sky130_fd_sc_hd__a21oi_2
XFILLER_12_131 VGND VGND VPWR VPWR sky130_fd_sc_hd__decap_3
XFILLER_16_94 VGND VGND VPWR VPWR sky130_fd_sc_hd__decap_3
X_552_ _552_/A _552_/B VGND VGND VPWR VPWR _552_/Y sky130_fd_sc_hd__nand2_2
X_483_ _473_/X _476_/Y _475_/Y _471_/A VGND VGND VPWR VPWR _506_/A sky130_fd_sc_hd__o211a_2
XTAP_TAPCELL_ROW_14_126 VGND VPWR sky130_fd_sc_hd__tapvpwrvgnd_1
XFILLER_12_186 VGND VGND VPWR VPWR sky130_fd_sc_hd__decap_3
XTAP_TAPCELL_ROW_3_86 VGND VPWR sky130_fd_sc_hd__tapvpwrvgnd_1
XFILLER_8_168 VGND VGND VPWR VPWR sky130_fd_sc_hd__decap_3
XFILLER_8_135 VGND VGND VPWR VPWR sky130_fd_sc_hd__decap_3
XFILLER_8_124 VGND VGND VPWR VPWR sky130_fd_sc_hd__decap_3
Xrebuffer221 _401_/Y VGND VGND VPWR VPWR _419_/A2 sky130_fd_sc_hd__buf_2
XFILLER_5_138 VGND VGND VPWR VPWR sky130_fd_sc_hd__decap_3
X_535_ _545_/A _533_/B _535_/B1 VGND VGND VPWR VPWR _535_/Y sky130_fd_sc_hd__o21ai_2
X_604_ _601_/Y _603_/X _602_/Y VGND VGND VPWR VPWR _604_/Y sky130_fd_sc_hd__o21ai_4
XFILLER_27_82 VGND VGND VPWR VPWR sky130_fd_sc_hd__decap_3
XFILLER_27_60 VGND VGND VPWR VPWR sky130_fd_sc_hd__decap_3
X_466_ _466_/A _466_/B VGND VGND VPWR VPWR _466_/X sky130_fd_sc_hd__and2_2
X_397_ _565_/A _395_/B _397_/B1 VGND VGND VPWR VPWR _397_/Y sky130_fd_sc_hd__o21ai_4
XFILLER_4_97 VGND VGND VPWR VPWR sky130_fd_sc_hd__decap_3
XFILLER_4_53 VGND VGND VPWR VPWR sky130_fd_sc_hd__decap_3
XTAP_TAPCELL_ROW_0_76 VGND VPWR sky130_fd_sc_hd__tapvpwrvgnd_1
X_518_ _519_/B _519_/A VGND VGND VPWR VPWR _518_/X sky130_fd_sc_hd__and2_2
X_449_ _459_/A _449_/B VGND VGND VPWR VPWR _450_/B sky130_fd_sc_hd__and2_2
XFILLER_18_29 VGND VGND VPWR VPWR sky130_fd_sc_hd__decap_3
XFILLER_6_200 VGND VGND VPWR VPWR sky130_fd_sc_hd__fill_2
XFILLER_24_83 VGND VGND VPWR VPWR sky130_fd_sc_hd__fill_1
XFILLER_24_50 VGND VGND VPWR VPWR sky130_fd_sc_hd__decap_3
XFILLER_1_98 VGND VGND VPWR VPWR sky130_fd_sc_hd__fill_2
XFILLER_1_10 VGND VGND VPWR VPWR sky130_fd_sc_hd__decap_3
XFILLER_10_41 VGND VGND VPWR VPWR sky130_fd_sc_hd__fill_2
XFILLER_10_74 VGND VGND VPWR VPWR sky130_fd_sc_hd__fill_1
XFILLER_10_85 VGND VGND VPWR VPWR sky130_fd_sc_hd__decap_3
XFILLER_19_72 VGND VGND VPWR VPWR sky130_fd_sc_hd__decap_3
XFILLER_19_50 VGND VGND VPWR VPWR sky130_fd_sc_hd__decap_3
XTAP_TAPCELL_ROW_6_97 VGND VPWR sky130_fd_sc_hd__tapvpwrvgnd_1
XPHY_EDGE_ROW_27_Left_63 VGND VGND VPWR VPWR sky130_fd_sc_hd__decap_3
XPHY_EDGE_ROW_11_Left_47 VGND VGND VPWR VPWR sky130_fd_sc_hd__decap_3
XFILLER_18_192 VGND VGND VPWR VPWR sky130_fd_sc_hd__decap_3
XFILLER_33_162 VGND VGND VPWR VPWR sky130_fd_sc_hd__decap_3
XFILLER_16_118 VGND VGND VPWR VPWR sky130_fd_sc_hd__fill_1
XTAP_TAPCELL_ROW_26_168 VGND VPWR sky130_fd_sc_hd__tapvpwrvgnd_1
XFILLER_24_184 VGND VGND VPWR VPWR sky130_fd_sc_hd__decap_3
XFILLER_21_73 VGND VGND VPWR VPWR sky130_fd_sc_hd__decap_3
XFILLER_21_51 VGND VGND VPWR VPWR sky130_fd_sc_hd__decap_3
XFILLER_21_84 VGND VGND VPWR VPWR sky130_fd_sc_hd__decap_3
X_697_ _694_/Y _695_/X input32/X VGND VGND VPWR VPWR _709_/B sky130_fd_sc_hd__o21bai_4
XTAP_TAPCELL_ROW_17_135 VGND VPWR sky130_fd_sc_hd__tapvpwrvgnd_1
XFILLER_15_151 VGND VGND VPWR VPWR sky130_fd_sc_hd__decap_3
XFILLER_15_184 VGND VGND VPWR VPWR sky130_fd_sc_hd__decap_3
XFILLER_30_187 VGND VGND VPWR VPWR sky130_fd_sc_hd__fill_1
XFILLER_30_121 VGND VGND VPWR VPWR sky130_fd_sc_hd__decap_3
XPHY_EDGE_ROW_5_Right_5 VGND VGND VPWR VPWR sky130_fd_sc_hd__decap_3
XFILLER_21_143 VGND VGND VPWR VPWR sky130_fd_sc_hd__decap_3
XTAP_TAPCELL_ROW_8_103 VGND VPWR sky130_fd_sc_hd__tapvpwrvgnd_1
X_551_ _542_/Y _551_/B _571_/B VGND VGND VPWR VPWR _552_/B sky130_fd_sc_hd__nand3b_4
X_620_ _620_/A _620_/B VGND VGND VPWR VPWR _620_/X sky130_fd_sc_hd__xor2_2
XFILLER_12_165 VGND VGND VPWR VPWR sky130_fd_sc_hd__decap_3
XFILLER_16_51 VGND VGND VPWR VPWR sky130_fd_sc_hd__decap_3
X_482_ _482_/A _482_/B VGND VGND VPWR VPWR _482_/Y sky130_fd_sc_hd__nand2_4
XTAP_TAPCELL_ROW_14_127 VGND VPWR sky130_fd_sc_hd__tapvpwrvgnd_1
XFILLER_8_114 VGND VGND VPWR VPWR sky130_fd_sc_hd__fill_1
XTAP_TAPCELL_ROW_3_87 VGND VPWR sky130_fd_sc_hd__tapvpwrvgnd_1
XFILLER_8_147 VGND VGND VPWR VPWR sky130_fd_sc_hd__decap_3
XFILLER_32_94 VGND VGND VPWR VPWR sky130_fd_sc_hd__fill_2
XPHY_EDGE_ROW_14_Left_50 VGND VGND VPWR VPWR sky130_fd_sc_hd__decap_3
X_534_ _532_/Y _533_/X _535_/B1 VGND VGND VPWR VPWR _534_/X sky130_fd_sc_hd__o21ba_2
X_603_ _605_/A _605_/D _596_/Y VGND VGND VPWR VPWR _603_/X sky130_fd_sc_hd__a21o_2
X_465_ _519_/B VGND VGND VPWR VPWR _465_/Y sky130_fd_sc_hd__inv_2
XFILLER_27_94 VGND VGND VPWR VPWR sky130_fd_sc_hd__decap_3
X_396_ _395_/X _394_/Y _397_/B1 VGND VGND VPWR VPWR _418_/A sky130_fd_sc_hd__o21bai_4
XFILLER_4_32 VGND VGND VPWR VPWR sky130_fd_sc_hd__fill_2
XFILLER_4_150 VGND VGND VPWR VPWR sky130_fd_sc_hd__decap_3
XTAP_TAPCELL_ROW_0_77 VGND VPWR sky130_fd_sc_hd__tapvpwrvgnd_1
X_517_ _469_/Y _519_/A _516_/Y VGND VGND VPWR VPWR _517_/Y sky130_fd_sc_hd__a21oi_2
X_448_ _459_/A _449_/B VGND VGND VPWR VPWR _450_/A sky130_fd_sc_hd__nor2_4
X_379_ _382_/B _379_/B VGND VGND VPWR VPWR _385_/B sky130_fd_sc_hd__nand2b_4
XFILLER_24_62 VGND VGND VPWR VPWR sky130_fd_sc_hd__decap_3
XFILLER_1_77 VGND VGND VPWR VPWR sky130_fd_sc_hd__decap_3
XFILLER_1_55 VGND VGND VPWR VPWR sky130_fd_sc_hd__fill_1
XFILLER_28_149 VGND VGND VPWR VPWR sky130_fd_sc_hd__decap_3
XFILLER_10_53 VGND VGND VPWR VPWR sky130_fd_sc_hd__decap_3
XFILLER_10_97 VGND VGND VPWR VPWR sky130_fd_sc_hd__fill_1
XTAP_TAPCELL_ROW_29_177 VGND VPWR sky130_fd_sc_hd__tapvpwrvgnd_1
XFILLER_19_40 VGND VGND VPWR VPWR sky130_fd_sc_hd__decap_3
XFILLER_19_105 VGND VGND VPWR VPWR sky130_fd_sc_hd__decap_3
XTAP_TAPCELL_ROW_6_98 VGND VPWR sky130_fd_sc_hd__tapvpwrvgnd_1
XFILLER_18_3 VGND VGND VPWR VPWR sky130_fd_sc_hd__fill_2
XTAP_TAPCELL_ROW_26_169 VGND VPWR sky130_fd_sc_hd__tapvpwrvgnd_1
X_696_ _694_/Y _695_/X input32/X VGND VGND VPWR VPWR _696_/X sky130_fd_sc_hd__o21ba_2
XTAP_TAPCELL_ROW_17_136 VGND VPWR sky130_fd_sc_hd__tapvpwrvgnd_1
XFILLER_15_163 VGND VGND VPWR VPWR sky130_fd_sc_hd__decap_3
XFILLER_30_144 VGND VGND VPWR VPWR sky130_fd_sc_hd__decap_3
XFILLER_30_100 VGND VGND VPWR VPWR sky130_fd_sc_hd__decap_3
XFILLER_7_87 VGND VGND VPWR VPWR sky130_fd_sc_hd__decap_3
XFILLER_21_155 VGND VGND VPWR VPWR sky130_fd_sc_hd__decap_3
XTAP_TAPCELL_ROW_8_104 VGND VPWR sky130_fd_sc_hd__tapvpwrvgnd_1
X_550_ _542_/Y _544_/A _571_/B VGND VGND VPWR VPWR _552_/A sky130_fd_sc_hd__o21bai_2
X_481_ _474_/X _477_/Y _479_/Y VGND VGND VPWR VPWR _482_/A sky130_fd_sc_hd__o21ai_2
XFILLER_12_122 VGND VGND VPWR VPWR sky130_fd_sc_hd__fill_2
XFILLER_12_144 VGND VGND VPWR VPWR sky130_fd_sc_hd__decap_3
XFILLER_12_177 VGND VGND VPWR VPWR sky130_fd_sc_hd__decap_3
XFILLER_16_85 VGND VGND VPWR VPWR sky130_fd_sc_hd__decap_3
XPHY_EDGE_ROW_11_Right_11 VGND VGND VPWR VPWR sky130_fd_sc_hd__decap_3
XFILLER_8_159 VGND VGND VPWR VPWR sky130_fd_sc_hd__decap_3
XFILLER_32_40 VGND VGND VPWR VPWR sky130_fd_sc_hd__decap_3
XTAP_TAPCELL_ROW_3_88 VGND VPWR sky130_fd_sc_hd__tapvpwrvgnd_1
XPHY_EDGE_ROW_20_Right_20 VGND VGND VPWR VPWR sky130_fd_sc_hd__decap_3
X_679_ _665_/A _666_/Y _691_/B _677_/Y VGND VGND VPWR VPWR _679_/Y sky130_fd_sc_hd__o211ai_2
X_602_ _598_/Y _601_/Y _596_/Y VGND VGND VPWR VPWR _602_/Y sky130_fd_sc_hd__o21ai_2
X_533_ _546_/A _533_/B VGND VGND VPWR VPWR _533_/X sky130_fd_sc_hd__and2_4
X_464_ _659_/Y _464_/B _464_/C _464_/D VGND VGND VPWR VPWR _519_/B sky130_fd_sc_hd__nor4_4
X_395_ _565_/A _395_/B VGND VGND VPWR VPWR _395_/X sky130_fd_sc_hd__and2_4
XFILLER_4_44 VGND VGND VPWR VPWR sky130_fd_sc_hd__decap_3
XFILLER_4_22 VGND VGND VPWR VPWR sky130_fd_sc_hd__decap_3
XFILLER_4_195 VGND VGND VPWR VPWR sky130_fd_sc_hd__fill_1
XFILLER_4_184 VGND VGND VPWR VPWR sky130_fd_sc_hd__decap_3
XFILLER_13_53 VGND VGND VPWR VPWR sky130_fd_sc_hd__decap_3
XTAP_TAPCELL_ROW_0_78 VGND VPWR sky130_fd_sc_hd__tapvpwrvgnd_1
X_516_ _506_/B _503_/X _508_/Y _500_/X VGND VGND VPWR VPWR _516_/Y sky130_fd_sc_hd__a31oi_2
X_447_ _464_/C _447_/B _693_/X _447_/D VGND VGND VPWR VPWR _456_/A sky130_fd_sc_hd__nand4b_2
X_378_ _378_/A _378_/B VGND VGND VPWR VPWR _378_/X sky130_fd_sc_hd__or2_4
XFILLER_24_85 VGND VGND VPWR VPWR sky130_fd_sc_hd__decap_3
XFILLER_24_41 VGND VGND VPWR VPWR sky130_fd_sc_hd__decap_3
XFILLER_10_32 VGND VGND VPWR VPWR sky130_fd_sc_hd__decap_3
XFILLER_10_65 VGND VGND VPWR VPWR sky130_fd_sc_hd__decap_3
XTAP_TAPCELL_ROW_29_178 VGND VPWR sky130_fd_sc_hd__tapvpwrvgnd_1
XFILLER_27_150 VGND VGND VPWR VPWR sky130_fd_sc_hd__decap_3
XFILLER_19_63 VGND VGND VPWR VPWR sky130_fd_sc_hd__decap_3
XTAP_TAPCELL_ROW_6_99 VGND VPWR sky130_fd_sc_hd__tapvpwrvgnd_1
XFILLER_0_208 VGND VGND VPWR VPWR sky130_fd_sc_hd__decap_3
XFILLER_16_109 VGND VGND VPWR VPWR sky130_fd_sc_hd__decap_3
XFILLER_24_164 VGND VGND VPWR VPWR sky130_fd_sc_hd__decap_3
XFILLER_21_42 VGND VGND VPWR VPWR sky130_fd_sc_hd__decap_3
XFILLER_15_142 VGND VGND VPWR VPWR sky130_fd_sc_hd__decap_3
X_695_ _695_/A _695_/B VGND VGND VPWR VPWR _695_/X sky130_fd_sc_hd__and2_4
XTAP_TAPCELL_ROW_17_137 VGND VPWR sky130_fd_sc_hd__tapvpwrvgnd_1
XFILLER_30_112 VGND VGND VPWR VPWR sky130_fd_sc_hd__decap_3
XFILLER_7_55 VGND VGND VPWR VPWR sky130_fd_sc_hd__fill_1
XFILLER_30_178 VGND VGND VPWR VPWR sky130_fd_sc_hd__decap_3
XFILLER_21_178 VGND VGND VPWR VPWR sky130_fd_sc_hd__decap_3
XFILLER_21_167 VGND VGND VPWR VPWR sky130_fd_sc_hd__fill_1
XFILLER_21_134 VGND VGND VPWR VPWR sky130_fd_sc_hd__decap_3
XTAP_TAPCELL_ROW_8_105 VGND VPWR sky130_fd_sc_hd__tapvpwrvgnd_1
XTAP_TAPCELL_ROW_31_184 VGND VPWR sky130_fd_sc_hd__tapvpwrvgnd_1
XFILLER_16_42 VGND VGND VPWR VPWR sky130_fd_sc_hd__decap_3
XFILLER_16_75 VGND VGND VPWR VPWR sky130_fd_sc_hd__decap_3
X_480_ _507_/A _471_/A _515_/A _515_/C VGND VGND VPWR VPWR _482_/B sky130_fd_sc_hd__a211o_2
XFILLER_12_134 VGND VGND VPWR VPWR sky130_fd_sc_hd__decap_3
XFILLER_12_156 VGND VGND VPWR VPWR sky130_fd_sc_hd__decap_3
XFILLER_12_189 VGND VGND VPWR VPWR sky130_fd_sc_hd__decap_3
XFILLER_16_97 VGND VGND VPWR VPWR sky130_fd_sc_hd__decap_3
XFILLER_8_138 VGND VGND VPWR VPWR sky130_fd_sc_hd__fill_2
XFILLER_8_127 VGND VGND VPWR VPWR sky130_fd_sc_hd__fill_1
XFILLER_8_105 VGND VGND VPWR VPWR sky130_fd_sc_hd__decap_3
X_678_ _665_/Y input6/X _676_/Y _691_/C VGND VGND VPWR VPWR _678_/Y sky130_fd_sc_hd__a22oi_2
X_601_ _601_/A VGND VGND VPWR VPWR _601_/Y sky130_fd_sc_hd__inv_2
XFILLER_27_63 VGND VGND VPWR VPWR sky130_fd_sc_hd__decap_3
XFILLER_27_30 VGND VGND VPWR VPWR sky130_fd_sc_hd__decap_3
X_532_ _545_/A _533_/B VGND VGND VPWR VPWR _532_/Y sky130_fd_sc_hd__nor2_2
X_463_ _515_/A _515_/D VGND VGND VPWR VPWR _471_/A sky130_fd_sc_hd__nor2_2
X_394_ _394_/A _395_/B VGND VGND VPWR VPWR _394_/Y sky130_fd_sc_hd__nor2_2
XFILLER_27_85 VGND VGND VPWR VPWR sky130_fd_sc_hd__decap_3
XTAP_TAPCELL_ROW_10_110 VGND VPWR sky130_fd_sc_hd__tapvpwrvgnd_1
XFILLER_4_141 VGND VGND VPWR VPWR sky130_fd_sc_hd__decap_3
XFILLER_4_130 VGND VGND VPWR VPWR sky130_fd_sc_hd__fill_2
XFILLER_4_56 VGND VGND VPWR VPWR sky130_fd_sc_hd__decap_3
XFILLER_8_3 VGND VGND VPWR VPWR sky130_fd_sc_hd__fill_2
XFILLER_1_177 VGND VGND VPWR VPWR sky130_fd_sc_hd__fill_1
X_515_ _515_/A _515_/B _515_/C _515_/D VGND VGND VPWR VPWR _519_/A sky130_fd_sc_hd__nor4_4
X_446_ _443_/X _440_/B _440_/A VGND VGND VPWR VPWR _466_/A sky130_fd_sc_hd__a21boi_2
X_377_ _378_/B _378_/A VGND VGND VPWR VPWR _420_/B sky130_fd_sc_hd__nor2_4
XFILLER_24_53 VGND VGND VPWR VPWR sky130_fd_sc_hd__decap_3
XFILLER_1_57 VGND VGND VPWR VPWR sky130_fd_sc_hd__decap_3
X_429_ _426_/Y _429_/B _429_/C VGND VGND VPWR VPWR _442_/B sky130_fd_sc_hd__nand3b_2
Xinput1 A[0] VGND VGND VPWR VPWR _615_/A sky130_fd_sc_hd__clkdlybuf4s25_1
XFILLER_10_11 VGND VGND VPWR VPWR sky130_fd_sc_hd__fill_1
XFILLER_10_88 VGND VGND VPWR VPWR sky130_fd_sc_hd__decap_3
XFILLER_19_53 VGND VGND VPWR VPWR sky130_fd_sc_hd__decap_3
XTAP_TAPCELL_ROW_29_179 VGND VPWR sky130_fd_sc_hd__tapvpwrvgnd_1
XFILLER_35_85 VGND VGND VPWR VPWR sky130_fd_sc_hd__fill_2
XFILLER_35_41 VGND VGND VPWR VPWR sky130_fd_sc_hd__decap_3
XFILLER_19_75 VGND VGND VPWR VPWR sky130_fd_sc_hd__fill_2
XFILLER_33_165 VGND VGND VPWR VPWR sky130_fd_sc_hd__decap_3
XFILLER_33_121 VGND VGND VPWR VPWR sky130_fd_sc_hd__decap_3
XFILLER_18_195 VGND VGND VPWR VPWR sky130_fd_sc_hd__fill_1
XFILLER_24_187 VGND VGND VPWR VPWR sky130_fd_sc_hd__decap_3
XFILLER_21_87 VGND VGND VPWR VPWR sky130_fd_sc_hd__decap_3
XFILLER_21_54 VGND VGND VPWR VPWR sky130_fd_sc_hd__fill_2
X_694_ _695_/A _695_/B VGND VGND VPWR VPWR _694_/Y sky130_fd_sc_hd__nor2_2
XFILLER_15_154 VGND VGND VPWR VPWR sky130_fd_sc_hd__decap_3
XFILLER_30_124 VGND VGND VPWR VPWR sky130_fd_sc_hd__decap_3
XTAP_TAPCELL_ROW_31_185 VGND VPWR sky130_fd_sc_hd__tapvpwrvgnd_1
XFILLER_21_146 VGND VGND VPWR VPWR sky130_fd_sc_hd__decap_3
XFILLER_21_113 VGND VGND VPWR VPWR sky130_fd_sc_hd__decap_3
XTAP_TAPCELL_ROW_8_106 VGND VPWR sky130_fd_sc_hd__tapvpwrvgnd_1
XFILLER_16_54 VGND VGND VPWR VPWR sky130_fd_sc_hd__decap_3
XFILLER_12_168 VGND VGND VPWR VPWR sky130_fd_sc_hd__decap_3
XTAP_TAPCELL_ROW_22_152 VGND VPWR sky130_fd_sc_hd__tapvpwrvgnd_1
XFILLER_32_75 VGND VGND VPWR VPWR sky130_fd_sc_hd__decap_3
X_677_ _689_/A _677_/B _677_/C VGND VGND VPWR VPWR _677_/Y sky130_fd_sc_hd__nand3_2
XPHY_EDGE_ROW_9_Right_9 VGND VGND VPWR VPWR sky130_fd_sc_hd__decap_3
XFILLER_7_172 VGND VGND VPWR VPWR sky130_fd_sc_hd__decap_3
XFILLER_7_150 VGND VGND VPWR VPWR sky130_fd_sc_hd__decap_3
X_531_ _538_/B _531_/B VGND VGND VPWR VPWR _531_/X sky130_fd_sc_hd__and2_4
X_600_ _585_/X _597_/B _597_/C VGND VGND VPWR VPWR _601_/A sky130_fd_sc_hd__o21a_2
X_462_ _458_/X _459_/Y _460_/B1 VGND VGND VPWR VPWR _515_/D sky130_fd_sc_hd__o21ba_2
X_393_ _617_/B _393_/B VGND VGND VPWR VPWR _410_/C sky130_fd_sc_hd__nor2_4
XFILLER_27_97 VGND VGND VPWR VPWR sky130_fd_sc_hd__decap_3
XTAP_TAPCELL_ROW_10_111 VGND VPWR sky130_fd_sc_hd__tapvpwrvgnd_1
XFILLER_4_153 VGND VGND VPWR VPWR sky130_fd_sc_hd__decap_3
XFILLER_4_197 VGND VGND VPWR VPWR sky130_fd_sc_hd__fill_1
X_729_ _730_/B1 _729_/B _729_/C VGND VGND VPWR VPWR _729_/Y sky130_fd_sc_hd__nand3b_4
XPHY_EDGE_ROW_18_Left_54 VGND VGND VPWR VPWR sky130_fd_sc_hd__decap_3
XFILLER_13_44 VGND VGND VPWR VPWR sky130_fd_sc_hd__decap_3
X_514_ _499_/X _502_/Y _501_/Y _491_/Y _506_/C VGND VGND VPWR VPWR _515_/B sky130_fd_sc_hd__o2111ai_2
X_445_ _445_/A _464_/C VGND VGND VPWR VPWR _445_/X sky130_fd_sc_hd__xor2_2
X_376_ _365_/Y _376_/B _376_/C _376_/D VGND VGND VPWR VPWR _378_/B sky130_fd_sc_hd__nand4b_4
XPHY_EDGE_ROW_3_Left_39 VGND VGND VPWR VPWR sky130_fd_sc_hd__decap_3
XFILLER_24_65 VGND VGND VPWR VPWR sky130_fd_sc_hd__decap_3
XFILLER_24_32 VGND VGND VPWR VPWR sky130_fd_sc_hd__decap_3
X_428_ _436_/A _428_/B VGND VGND VPWR VPWR _429_/B sky130_fd_sc_hd__nand2_2
X_359_ _354_/X _353_/Y _357_/Y _358_/B VGND VGND VPWR VPWR _406_/A sky130_fd_sc_hd__a22oi_4
Xinput2 A[10] VGND VGND VPWR VPWR input2/X sky130_fd_sc_hd__clkdlybuf4s25_1
XFILLER_10_56 VGND VGND VPWR VPWR sky130_fd_sc_hd__decap_3
XFILLER_19_108 VGND VGND VPWR VPWR sky130_fd_sc_hd__decap_3
XFILLER_27_141 VGND VGND VPWR VPWR sky130_fd_sc_hd__decap_3
XFILLER_18_163 VGND VGND VPWR VPWR sky130_fd_sc_hd__fill_2
XFILLER_18_130 VGND VGND VPWR VPWR sky130_fd_sc_hd__decap_3
XFILLER_24_111 VGND VGND VPWR VPWR sky130_fd_sc_hd__decap_3
XTAP_TAPCELL_ROW_34_194 VGND VPWR sky130_fd_sc_hd__tapvpwrvgnd_1
X_693_ _691_/X _692_/B _692_/C _688_/X _685_/Y VGND VGND VPWR VPWR _693_/X sky130_fd_sc_hd__a41o_2
XPHY_EDGE_ROW_6_Left_42 VGND VGND VPWR VPWR sky130_fd_sc_hd__decap_3
XFILLER_15_111 VGND VGND VPWR VPWR sky130_fd_sc_hd__fill_1
XFILLER_15_166 VGND VGND VPWR VPWR sky130_fd_sc_hd__fill_2
XFILLER_30_169 VGND VGND VPWR VPWR sky130_fd_sc_hd__decap_3
XFILLER_30_147 VGND VGND VPWR VPWR sky130_fd_sc_hd__decap_3
XFILLER_30_103 VGND VGND VPWR VPWR sky130_fd_sc_hd__decap_3
XFILLER_7_57 VGND VGND VPWR VPWR sky130_fd_sc_hd__decap_3
XFILLER_16_3 VGND VGND VPWR VPWR sky130_fd_sc_hd__fill_2
XFILLER_21_103 VGND VGND VPWR VPWR sky130_fd_sc_hd__decap_3
XTAP_TAPCELL_ROW_31_186 VGND VPWR sky130_fd_sc_hd__tapvpwrvgnd_1
XFILLER_21_169 VGND VGND VPWR VPWR sky130_fd_sc_hd__decap_3
XFILLER_21_158 VGND VGND VPWR VPWR sky130_fd_sc_hd__decap_3
XFILLER_21_125 VGND VGND VPWR VPWR sky130_fd_sc_hd__decap_3
Xinput60 B[5] VGND VGND VPWR VPWR _353_/B sky130_fd_sc_hd__clkdlybuf4s25_1
XFILLER_12_147 VGND VGND VPWR VPWR sky130_fd_sc_hd__fill_2
XFILLER_16_88 VGND VGND VPWR VPWR sky130_fd_sc_hd__decap_3
XPHY_EDGE_ROW_32_Left_68 VGND VGND VPWR VPWR sky130_fd_sc_hd__decap_3
XTAP_TAPCELL_ROW_22_153 VGND VPWR sky130_fd_sc_hd__tapvpwrvgnd_1
XFILLER_32_43 VGND VGND VPWR VPWR sky130_fd_sc_hd__decap_3
XFILLER_20_180 VGND VGND VPWR VPWR sky130_fd_sc_hd__fill_1
X_676_ _674_/B _675_/Y _691_/B VGND VGND VPWR VPWR _676_/Y sky130_fd_sc_hd__o21ai_2
XFILLER_11_191 VGND VGND VPWR VPWR sky130_fd_sc_hd__decap_3
X_530_ _425_/B _530_/A2 _558_/A _517_/Y VGND VGND VPWR VPWR _531_/B sky130_fd_sc_hd__o211ai_2
X_461_ _459_/A _459_/B _460_/Y VGND VGND VPWR VPWR _515_/A sky130_fd_sc_hd__a21oi_2
XFILLER_27_54 VGND VGND VPWR VPWR sky130_fd_sc_hd__fill_2
XFILLER_17_206 VGND VGND VPWR VPWR sky130_fd_sc_hd__decap_3
X_392_ _616_/S _389_/Y _379_/B _391_/Y VGND VGND VPWR VPWR _393_/B sky130_fd_sc_hd__o211ai_2
XTAP_TAPCELL_ROW_10_112 VGND VPWR sky130_fd_sc_hd__tapvpwrvgnd_1
XFILLER_4_47 VGND VGND VPWR VPWR sky130_fd_sc_hd__decap_3
XFILLER_4_25 VGND VGND VPWR VPWR sky130_fd_sc_hd__decap_3
XFILLER_4_187 VGND VGND VPWR VPWR sky130_fd_sc_hd__fill_1
XFILLER_4_165 VGND VGND VPWR VPWR sky130_fd_sc_hd__fill_1
XFILLER_4_121 VGND VGND VPWR VPWR sky130_fd_sc_hd__decap_3
X_659_ _659_/A _659_/B VGND VGND VPWR VPWR _659_/Y sky130_fd_sc_hd__nand2_2
X_728_ _728_/A _728_/B VGND VGND VPWR VPWR _728_/X sky130_fd_sc_hd__and2_2
XTAP_TAPCELL_ROW_4_90 VGND VPWR sky130_fd_sc_hd__tapvpwrvgnd_1
XFILLER_13_34 VGND VGND VPWR VPWR sky130_fd_sc_hd__fill_2
XFILLER_1_113 VGND VGND VPWR VPWR sky130_fd_sc_hd__fill_2
XFILLER_1_157 VGND VGND VPWR VPWR sky130_fd_sc_hd__fill_2
X_513_ _513_/A _513_/B VGND VGND VPWR VPWR _513_/Y sky130_fd_sc_hd__nor2_4
X_444_ _447_/D _693_/X _447_/B _443_/X VGND VGND VPWR VPWR _445_/A sky130_fd_sc_hd__a31oi_4
X_375_ _369_/Y _373_/X _411_/C VGND VGND VPWR VPWR _631_/A sky130_fd_sc_hd__o21ai_2
XPHY_EDGE_ROW_35_Left_71 VGND VGND VPWR VPWR sky130_fd_sc_hd__decap_3
XFILLER_24_22 VGND VGND VPWR VPWR sky130_fd_sc_hd__decap_3
XFILLER_24_88 VGND VGND VPWR VPWR sky130_fd_sc_hd__fill_2
XFILLER_24_77 VGND VGND VPWR VPWR sky130_fd_sc_hd__decap_3
XFILLER_24_44 VGND VGND VPWR VPWR sky130_fd_sc_hd__decap_3
XFILLER_1_26 VGND VGND VPWR VPWR sky130_fd_sc_hd__fill_1
X_427_ _436_/A _428_/B VGND VGND VPWR VPWR _427_/X sky130_fd_sc_hd__and2_4
X_358_ _653_/Y _358_/B _358_/C VGND VGND VPWR VPWR _358_/Y sky130_fd_sc_hd__nand3_2
XTAP_TAPCELL_ROW_1_80 VGND VPWR sky130_fd_sc_hd__tapvpwrvgnd_1
XPHY_EDGE_ROW_18_Right_18 VGND VGND VPWR VPWR sky130_fd_sc_hd__decap_3
Xinput3 A[11] VGND VGND VPWR VPWR input3/X sky130_fd_sc_hd__clkdlybuf4s25_1
XPHY_EDGE_ROW_27_Right_27 VGND VGND VPWR VPWR sky130_fd_sc_hd__decap_3
XFILLER_10_35 VGND VGND VPWR VPWR sky130_fd_sc_hd__decap_3
XFILLER_10_68 VGND VGND VPWR VPWR sky130_fd_sc_hd__decap_3
XFILLER_27_153 VGND VGND VPWR VPWR sky130_fd_sc_hd__fill_2
XFILLER_19_66 VGND VGND VPWR VPWR sky130_fd_sc_hd__decap_3
XFILLER_33_178 VGND VGND VPWR VPWR sky130_fd_sc_hd__fill_1
XFILLER_33_156 VGND VGND VPWR VPWR sky130_fd_sc_hd__decap_3
XFILLER_2_80 VGND VGND VPWR VPWR sky130_fd_sc_hd__decap_3
XFILLER_24_178 VGND VGND VPWR VPWR sky130_fd_sc_hd__decap_3
XTAP_TAPCELL_ROW_34_195 VGND VPWR sky130_fd_sc_hd__tapvpwrvgnd_1
XFILLER_21_45 VGND VGND VPWR VPWR sky130_fd_sc_hd__decap_3
X_692_ _692_/A _692_/B _692_/C _692_/D VGND VGND VPWR VPWR _692_/X sky130_fd_sc_hd__and4_4
XFILLER_15_145 VGND VGND VPWR VPWR sky130_fd_sc_hd__decap_3
XFILLER_30_115 VGND VGND VPWR VPWR sky130_fd_sc_hd__decap_3
Xinput50 B[25] VGND VGND VPWR VPWR _533_/B sky130_fd_sc_hd__clkdlybuf4s25_1
Xinput61 B[6] VGND VGND VPWR VPWR _728_/B sky130_fd_sc_hd__clkdlybuf4s25_1
XFILLER_21_137 VGND VGND VPWR VPWR sky130_fd_sc_hd__decap_3
XFILLER_12_137 VGND VGND VPWR VPWR sky130_fd_sc_hd__decap_3
XFILLER_12_159 VGND VGND VPWR VPWR sky130_fd_sc_hd__decap_3
XFILLER_16_45 VGND VGND VPWR VPWR sky130_fd_sc_hd__decap_3
XFILLER_16_78 VGND VGND VPWR VPWR sky130_fd_sc_hd__decap_3
XTAP_TAPCELL_ROW_22_154 VGND VPWR sky130_fd_sc_hd__tapvpwrvgnd_1
XPHY_EDGE_ROW_0_Right_0 VGND VGND VPWR VPWR sky130_fd_sc_hd__decap_3
XFILLER_8_108 VGND VGND VPWR VPWR sky130_fd_sc_hd__decap_3
X_675_ _675_/A1 _673_/B _677_/C VGND VGND VPWR VPWR _675_/Y sky130_fd_sc_hd__o21ai_2
XTAP_TAPCELL_ROW_13_121 VGND VPWR sky130_fd_sc_hd__tapvpwrvgnd_1
XFILLER_7_130 VGND VGND VPWR VPWR sky130_fd_sc_hd__fill_1
X_460_ _459_/A _459_/B _460_/B1 VGND VGND VPWR VPWR _460_/Y sky130_fd_sc_hd__o21ai_4
X_391_ _387_/X _388_/Y _615_/A VGND VGND VPWR VPWR _391_/Y sky130_fd_sc_hd__o21bai_2
XFILLER_27_88 VGND VGND VPWR VPWR sky130_fd_sc_hd__decap_3
XFILLER_27_33 VGND VGND VPWR VPWR sky130_fd_sc_hd__decap_3
XTAP_TAPCELL_ROW_10_113 VGND VPWR sky130_fd_sc_hd__tapvpwrvgnd_1
XFILLER_4_59 VGND VGND VPWR VPWR sky130_fd_sc_hd__decap_3
XFILLER_4_144 VGND VGND VPWR VPWR sky130_fd_sc_hd__decap_3
XFILLER_4_100 VGND VGND VPWR VPWR sky130_fd_sc_hd__decap_3
X_727_ _727_/A _728_/B VGND VGND VPWR VPWR _729_/C sky130_fd_sc_hd__nand2_2
X_589_ _568_/Y _579_/Y _587_/Y VGND VGND VPWR VPWR _589_/Y sky130_fd_sc_hd__o21ai_2
X_658_ _654_/Y _655_/X _657_/C VGND VGND VPWR VPWR _659_/B sky130_fd_sc_hd__o21bai_4
XTAP_TAPCELL_ROW_4_91 VGND VPWR sky130_fd_sc_hd__tapvpwrvgnd_1
XFILLER_22_210 VGND VGND VPWR VPWR sky130_fd_sc_hd__fill_1
XFILLER_13_57 VGND VGND VPWR VPWR sky130_fd_sc_hd__decap_3
XFILLER_13_68 VGND VGND VPWR VPWR sky130_fd_sc_hd__decap_3
XFILLER_13_210 VGND VGND VPWR VPWR sky130_fd_sc_hd__fill_1
X_512_ _507_/Y _510_/X _505_/Y VGND VGND VPWR VPWR _513_/A sky130_fd_sc_hd__a21oi_4
X_443_ _443_/A _443_/B VGND VGND VPWR VPWR _443_/X sky130_fd_sc_hd__and2_2
X_374_ _370_/A _370_/B _372_/Y VGND VGND VPWR VPWR _376_/D sky130_fd_sc_hd__o21ai_2
XFILLER_5_91 VGND VGND VPWR VPWR sky130_fd_sc_hd__decap_3
XFILLER_24_56 VGND VGND VPWR VPWR sky130_fd_sc_hd__decap_3
XFILLER_10_202 VGND VGND VPWR VPWR sky130_fd_sc_hd__fill_1
XFILLER_6_3 VGND VGND VPWR VPWR sky130_fd_sc_hd__decap_3
X_426_ _436_/A _428_/B VGND VGND VPWR VPWR _426_/Y sky130_fd_sc_hd__nor2_4
X_357_ _727_/A _353_/B _653_/A VGND VGND VPWR VPWR _357_/Y sky130_fd_sc_hd__a21oi_2
Xinput4 A[12] VGND VGND VPWR VPWR _677_/C sky130_fd_sc_hd__clkdlybuf4s25_1
XTAP_TAPCELL_ROW_1_81 VGND VPWR sky130_fd_sc_hd__tapvpwrvgnd_1
XFILLER_27_165 VGND VGND VPWR VPWR sky130_fd_sc_hd__decap_3
XFILLER_27_132 VGND VGND VPWR VPWR sky130_fd_sc_hd__decap_3
XFILLER_27_110 VGND VGND VPWR VPWR sky130_fd_sc_hd__fill_2
XFILLER_35_44 VGND VGND VPWR VPWR sky130_fd_sc_hd__decap_3
XFILLER_18_121 VGND VGND VPWR VPWR sky130_fd_sc_hd__fill_2
X_409_ _409_/A _409_/B VGND VGND VPWR VPWR _411_/A sky130_fd_sc_hd__nand2_4
XFILLER_2_92 VGND VGND VPWR VPWR sky130_fd_sc_hd__fill_1
XFILLER_24_102 VGND VGND VPWR VPWR sky130_fd_sc_hd__decap_3
XTAP_TAPCELL_ROW_34_196 VGND VPWR sky130_fd_sc_hd__tapvpwrvgnd_1
XFILLER_15_102 VGND VGND VPWR VPWR sky130_fd_sc_hd__decap_3
XFILLER_15_113 VGND VGND VPWR VPWR sky130_fd_sc_hd__decap_3
XFILLER_15_157 VGND VGND VPWR VPWR sky130_fd_sc_hd__decap_3
X_691_ _692_/A _691_/B _691_/C VGND VGND VPWR VPWR _691_/X sky130_fd_sc_hd__and3_2
Xmax_cap99 _517_/Y VGND VGND VPWR VPWR _559_/A2 sky130_fd_sc_hd__clkbuf_2
XTAP_TAPCELL_ROW_25_163 VGND VPWR sky130_fd_sc_hd__tapvpwrvgnd_1
XFILLER_30_127 VGND VGND VPWR VPWR sky130_fd_sc_hd__decap_3
XFILLER_21_149 VGND VGND VPWR VPWR sky130_fd_sc_hd__decap_3
Xinput40 B[16] VGND VGND VPWR VPWR _656_/A sky130_fd_sc_hd__clkdlybuf4s25_1
Xinput51 B[26] VGND VGND VPWR VPWR _546_/B sky130_fd_sc_hd__clkdlybuf4s25_1
Xinput62 B[7] VGND VGND VPWR VPWR _370_/B sky130_fd_sc_hd__clkdlybuf4s25_1
XTAP_TAPCELL_ROW_22_155 VGND VPWR sky130_fd_sc_hd__tapvpwrvgnd_1
XFILLER_32_78 VGND VGND VPWR VPWR sky130_fd_sc_hd__decap_3
XFILLER_20_171 VGND VGND VPWR VPWR sky130_fd_sc_hd__decap_3
X_674_ _674_/A _674_/B VGND VGND VPWR VPWR _677_/B sky130_fd_sc_hd__nor2_2
XTAP_TAPCELL_ROW_13_122 VGND VPWR sky130_fd_sc_hd__tapvpwrvgnd_1
XFILLER_11_160 VGND VGND VPWR VPWR sky130_fd_sc_hd__decap_3
XFILLER_11_182 VGND VGND VPWR VPWR sky130_fd_sc_hd__decap_3
XFILLER_7_175 VGND VGND VPWR VPWR sky130_fd_sc_hd__fill_2
XFILLER_7_153 VGND VGND VPWR VPWR sky130_fd_sc_hd__fill_2
XFILLER_8_91 VGND VGND VPWR VPWR sky130_fd_sc_hd__fill_1
X_390_ _379_/B _616_/S _389_/Y VGND VGND VPWR VPWR _390_/Y sky130_fd_sc_hd__a21oi_2
XFILLER_4_112 VGND VGND VPWR VPWR sky130_fd_sc_hd__decap_3
XFILLER_4_178 VGND VGND VPWR VPWR sky130_fd_sc_hd__decap_3
XFILLER_4_156 VGND VGND VPWR VPWR sky130_fd_sc_hd__fill_2
X_657_ _654_/Y _657_/B _657_/C VGND VGND VPWR VPWR _659_/A sky130_fd_sc_hd__nand3b_2
X_726_ _728_/B _728_/A VGND VGND VPWR VPWR _729_/B sky130_fd_sc_hd__nand2b_4
X_588_ _570_/Y _578_/Y _587_/Y VGND VGND VPWR VPWR _588_/Y sky130_fd_sc_hd__o21bai_2
XTAP_TAPCELL_ROW_4_92 VGND VPWR sky130_fd_sc_hd__tapvpwrvgnd_1
XFILLER_13_47 VGND VGND VPWR VPWR sky130_fd_sc_hd__decap_3
X_511_ _511_/A1 _507_/B _509_/Y _504_/X VGND VGND VPWR VPWR _513_/B sky130_fd_sc_hd__a211oi_4
X_442_ _659_/A _442_/B VGND VGND VPWR VPWR _443_/B sky130_fd_sc_hd__nand2_2
X_373_ _373_/A1 _370_/B input30/X VGND VGND VPWR VPWR _373_/X sky130_fd_sc_hd__a21bo_2
X_709_ _709_/A _709_/B _709_/C _709_/D VGND VGND VPWR VPWR _725_/B sky130_fd_sc_hd__nand4_4
XFILLER_24_68 VGND VGND VPWR VPWR sky130_fd_sc_hd__decap_3
XFILLER_24_35 VGND VGND VPWR VPWR sky130_fd_sc_hd__decap_3
X_425_ _659_/Y _425_/B VGND VGND VPWR VPWR _425_/X sky130_fd_sc_hd__xor2_2
X_356_ _356_/A1 _353_/B _355_/Y VGND VGND VPWR VPWR _356_/Y sky130_fd_sc_hd__o21ai_2
Xinput5 A[13] VGND VGND VPWR VPWR _671_/C sky130_fd_sc_hd__clkdlybuf4s25_1
XFILLER_27_144 VGND VGND VPWR VPWR sky130_fd_sc_hd__decap_3
XFILLER_27_100 VGND VGND VPWR VPWR sky130_fd_sc_hd__decap_3
XFILLER_19_57 VGND VGND VPWR VPWR sky130_fd_sc_hd__decap_3
XFILLER_18_133 VGND VGND VPWR VPWR sky130_fd_sc_hd__decap_3
XFILLER_18_100 VGND VGND VPWR VPWR sky130_fd_sc_hd__decap_3
X_408_ _373_/X _369_/Y _729_/Y _407_/Y VGND VGND VPWR VPWR _409_/B sky130_fd_sc_hd__a2bb2oi_2
XFILLER_24_114 VGND VGND VPWR VPWR sky130_fd_sc_hd__fill_2
XTAP_TAPCELL_ROW_34_197 VGND VPWR sky130_fd_sc_hd__tapvpwrvgnd_1
XFILLER_24_158 VGND VGND VPWR VPWR sky130_fd_sc_hd__decap_3
XFILLER_24_136 VGND VGND VPWR VPWR sky130_fd_sc_hd__decap_3
XFILLER_21_36 VGND VGND VPWR VPWR sky130_fd_sc_hd__fill_2
X_690_ _666_/Y _665_/A _689_/A _691_/B _680_/Y VGND VGND VPWR VPWR _692_/D sky130_fd_sc_hd__o2111a_2
XFILLER_15_136 VGND VGND VPWR VPWR sky130_fd_sc_hd__decap_3
XFILLER_15_169 VGND VGND VPWR VPWR sky130_fd_sc_hd__decap_3
XTAP_TAPCELL_ROW_25_164 VGND VPWR sky130_fd_sc_hd__tapvpwrvgnd_1
XFILLER_30_106 VGND VGND VPWR VPWR sky130_fd_sc_hd__decap_3
XFILLER_7_38 VGND VGND VPWR VPWR sky130_fd_sc_hd__decap_3
XTAP_TAPCELL_ROW_16_131 VGND VPWR sky130_fd_sc_hd__tapvpwrvgnd_1
XFILLER_21_128 VGND VGND VPWR VPWR sky130_fd_sc_hd__decap_3
XFILLER_21_106 VGND VGND VPWR VPWR sky130_fd_sc_hd__decap_3
Xinput30 A[7] VGND VGND VPWR VPWR input30/X sky130_fd_sc_hd__clkdlybuf4s25_1
Xinput41 B[17] VGND VGND VPWR VPWR _428_/B sky130_fd_sc_hd__clkdlybuf4s25_1
Xinput52 B[27] VGND VGND VPWR VPWR _554_/B sky130_fd_sc_hd__clkdlybuf4s25_1
Xinput63 B[8] VGND VGND VPWR VPWR _702_/B sky130_fd_sc_hd__clkdlybuf4s25_1
XFILLER_16_36 VGND VGND VPWR VPWR sky130_fd_sc_hd__decap_3
XFILLER_12_128 VGND VGND VPWR VPWR sky130_fd_sc_hd__decap_3
XFILLER_32_46 VGND VGND VPWR VPWR sky130_fd_sc_hd__decap_3
XFILLER_32_24 VGND VGND VPWR VPWR sky130_fd_sc_hd__decap_3
XFILLER_20_150 VGND VGND VPWR VPWR sky130_fd_sc_hd__decap_3
X_673_ _673_/A _673_/B VGND VGND VPWR VPWR _674_/B sky130_fd_sc_hd__and2_2
XTAP_TAPCELL_ROW_13_123 VGND VPWR sky130_fd_sc_hd__tapvpwrvgnd_1
XFILLER_11_194 VGND VGND VPWR VPWR sky130_fd_sc_hd__fill_1
XFILLER_7_198 VGND VGND VPWR VPWR sky130_fd_sc_hd__decap_3
XFILLER_8_70 VGND VGND VPWR VPWR sky130_fd_sc_hd__decap_3
XFILLER_27_57 VGND VGND VPWR VPWR sky130_fd_sc_hd__decap_3
XFILLER_17_209 VGND VGND VPWR VPWR sky130_fd_sc_hd__fill_2
XFILLER_27_79 VGND VGND VPWR VPWR sky130_fd_sc_hd__decap_3
XFILLER_4_124 VGND VGND VPWR VPWR sky130_fd_sc_hd__decap_3
X_587_ _597_/C _597_/D VGND VGND VPWR VPWR _587_/Y sky130_fd_sc_hd__nand2_2
X_656_ _656_/A _656_/B VGND VGND VPWR VPWR _657_/B sky130_fd_sc_hd__nand2_2
X_725_ _725_/A _725_/B VGND VGND VPWR VPWR _725_/Y sky130_fd_sc_hd__nor2_4
XFILLER_3_190 VGND VGND VPWR VPWR sky130_fd_sc_hd__decap_3
X_510_ _474_/X _484_/X _492_/X _506_/B VGND VGND VPWR VPWR _510_/X sky130_fd_sc_hd__o31a_2
X_441_ _659_/A _659_/B _442_/B _443_/A VGND VGND VPWR VPWR _447_/B sky130_fd_sc_hd__and4_2
X_372_ _373_/A1 _370_/B input30/X VGND VGND VPWR VPWR _372_/Y sky130_fd_sc_hd__a21boi_2
XFILLER_0_193 VGND VGND VPWR VPWR sky130_fd_sc_hd__decap_3
X_639_ _722_/X _639_/B VGND VGND VPWR VPWR _639_/X sky130_fd_sc_hd__xor2_2
X_708_ _709_/B _709_/A _709_/C _709_/D VGND VGND VPWR VPWR _708_/X sky130_fd_sc_hd__and4_2
XFILLER_24_47 VGND VGND VPWR VPWR sky130_fd_sc_hd__decap_3
XFILLER_24_25 VGND VGND VPWR VPWR sky130_fd_sc_hd__decap_3
X_424_ _692_/X _685_/Y _415_/Y _422_/Y VGND VGND VPWR VPWR _424_/Y sky130_fd_sc_hd__o22ai_4
XPHY_EDGE_ROW_23_Left_59 VGND VGND VPWR VPWR sky130_fd_sc_hd__decap_3
X_355_ _356_/A1 _353_/B _653_/A VGND VGND VPWR VPWR _355_/Y sky130_fd_sc_hd__a21boi_2
Xinput6 A[14] VGND VGND VPWR VPWR input6/X sky130_fd_sc_hd__clkdlybuf4s25_1
XFILLER_10_38 VGND VGND VPWR VPWR sky130_fd_sc_hd__decap_3
XFILLER_19_69 VGND VGND VPWR VPWR sky130_fd_sc_hd__decap_3
XFILLER_35_68 VGND VGND VPWR VPWR sky130_fd_sc_hd__fill_2
XFILLER_35_57 VGND VGND VPWR VPWR sky130_fd_sc_hd__decap_3
XFILLER_27_123 VGND VGND VPWR VPWR sky130_fd_sc_hd__decap_3
XPHY_EDGE_ROW_14_Right_14 VGND VGND VPWR VPWR sky130_fd_sc_hd__decap_3
XPHY_EDGE_ROW_23_Right_23 VGND VGND VPWR VPWR sky130_fd_sc_hd__decap_3
XFILLER_18_112 VGND VGND VPWR VPWR sky130_fd_sc_hd__decap_3
X_407_ _728_/X _730_/Y _356_/Y VGND VGND VPWR VPWR _407_/Y sky130_fd_sc_hd__o21ai_2
XTAP_TAPCELL_ROW_28_173 VGND VPWR sky130_fd_sc_hd__tapvpwrvgnd_1
XPHY_EDGE_ROW_32_Right_32 VGND VGND VPWR VPWR sky130_fd_sc_hd__decap_3
XFILLER_33_159 VGND VGND VPWR VPWR sky130_fd_sc_hd__decap_3
XFILLER_2_83 VGND VGND VPWR VPWR sky130_fd_sc_hd__fill_1
XFILLER_21_48 VGND VGND VPWR VPWR sky130_fd_sc_hd__decap_3
XFILLER_15_148 VGND VGND VPWR VPWR sky130_fd_sc_hd__decap_3
XTAP_TAPCELL_ROW_25_165 VGND VPWR sky130_fd_sc_hd__tapvpwrvgnd_1
XFILLER_30_118 VGND VGND VPWR VPWR sky130_fd_sc_hd__decap_3
XFILLER_11_81 VGND VGND VPWR VPWR sky130_fd_sc_hd__fill_1
XTAP_TAPCELL_ROW_16_132 VGND VPWR sky130_fd_sc_hd__tapvpwrvgnd_1
Xinput20 A[27] VGND VGND VPWR VPWR input20/X sky130_fd_sc_hd__clkdlybuf4s25_1
Xinput31 A[8] VGND VGND VPWR VPWR _704_/B1 sky130_fd_sc_hd__clkdlybuf4s25_1
XPHY_EDGE_ROW_26_Left_62 VGND VGND VPWR VPWR sky130_fd_sc_hd__decap_3
Xinput42 B[18] VGND VGND VPWR VPWR _436_/B sky130_fd_sc_hd__clkdlybuf4s25_1
Xinput53 B[28] VGND VGND VPWR VPWR _566_/B sky130_fd_sc_hd__clkdlybuf4s25_1
Xinput64 B[9] VGND VGND VPWR VPWR _695_/B sky130_fd_sc_hd__clkdlybuf4s25_1
XPHY_EDGE_ROW_10_Left_46 VGND VGND VPWR VPWR sky130_fd_sc_hd__decap_3
XFILLER_16_26 VGND VGND VPWR VPWR sky130_fd_sc_hd__fill_2
XFILLER_16_48 VGND VGND VPWR VPWR sky130_fd_sc_hd__decap_3
XFILLER_32_58 VGND VGND VPWR VPWR sky130_fd_sc_hd__decap_3
XFILLER_20_162 VGND VGND VPWR VPWR sky130_fd_sc_hd__decap_3
XTAP_TAPCELL_ROW_7_100 VGND VPWR sky130_fd_sc_hd__tapvpwrvgnd_1
X_672_ _673_/A _673_/B VGND VGND VPWR VPWR _674_/A sky130_fd_sc_hd__nor2_2
XFILLER_7_144 VGND VGND VPWR VPWR sky130_fd_sc_hd__decap_3
XFILLER_22_91 VGND VGND VPWR VPWR sky130_fd_sc_hd__decap_3
XFILLER_8_82 VGND VGND VPWR VPWR sky130_fd_sc_hd__fill_2
XPHY_EDGE_ROW_4_Right_4 VGND VGND VPWR VPWR sky130_fd_sc_hd__decap_3
XFILLER_27_36 VGND VGND VPWR VPWR sky130_fd_sc_hd__decap_3
XFILLER_25_210 VGND VGND VPWR VPWR sky130_fd_sc_hd__fill_1
XFILLER_4_29 VGND VGND VPWR VPWR sky130_fd_sc_hd__decap_3
XFILLER_4_147 VGND VGND VPWR VPWR sky130_fd_sc_hd__decap_3
XFILLER_4_103 VGND VGND VPWR VPWR sky130_fd_sc_hd__decap_3
X_724_ _718_/Y _717_/X _716_/B _716_/A _721_/Y VGND VGND VPWR VPWR _725_/A sky130_fd_sc_hd__o2111ai_4
XFILLER_16_210 VGND VGND VPWR VPWR sky130_fd_sc_hd__fill_1
X_586_ _584_/A _584_/B input22/X VGND VGND VPWR VPWR _597_/D sky130_fd_sc_hd__o21bai_2
X_655_ _656_/A _655_/B VGND VGND VPWR VPWR _655_/X sky130_fd_sc_hd__and2_4
XFILLER_1_128 VGND VGND VPWR VPWR sky130_fd_sc_hd__decap_3
X_440_ _440_/A _440_/B VGND VGND VPWR VPWR _464_/C sky130_fd_sc_hd__nand2_2
X_371_ _370_/X _369_/Y input30/X VGND VGND VPWR VPWR _376_/B sky130_fd_sc_hd__o21bai_4
X_707_ _709_/C _709_/D VGND VGND VPWR VPWR _707_/Y sky130_fd_sc_hd__nand2_2
X_569_ _569_/A _569_/B input21/X VGND VGND VPWR VPWR _597_/B sky130_fd_sc_hd__or3b_4
X_638_ _716_/Y _637_/B _716_/B VGND VGND VPWR VPWR _639_/B sky130_fd_sc_hd__o21ai_2
XFILLER_5_94 VGND VGND VPWR VPWR sky130_fd_sc_hd__decap_3
XFILLER_24_59 VGND VGND VPWR VPWR sky130_fd_sc_hd__decap_3
X_423_ _423_/A _640_/B _423_/C _640_/A VGND VGND VPWR VPWR _447_/D sky130_fd_sc_hd__nand4_4
X_354_ _363_/B _353_/B _653_/A VGND VGND VPWR VPWR _354_/X sky130_fd_sc_hd__o21a_2
XFILLER_14_81 VGND VGND VPWR VPWR sky130_fd_sc_hd__decap_3
XFILLER_30_91 VGND VGND VPWR VPWR sky130_fd_sc_hd__decap_3
Xinput7 A[15] VGND VGND VPWR VPWR input7/X sky130_fd_sc_hd__clkdlybuf4s25_1
XFILLER_27_135 VGND VGND VPWR VPWR sky130_fd_sc_hd__decap_3
XFILLER_27_113 VGND VGND VPWR VPWR sky130_fd_sc_hd__decap_3
XFILLER_35_47 VGND VGND VPWR VPWR sky130_fd_sc_hd__fill_1
XFILLER_4_3 VGND VGND VPWR VPWR sky130_fd_sc_hd__fill_2
XTAP_TAPCELL_ROW_28_174 VGND VPWR sky130_fd_sc_hd__tapvpwrvgnd_1
X_406_ _406_/A _406_/B _729_/Y _406_/D VGND VGND VPWR VPWR _409_/A sky130_fd_sc_hd__nand4_4
XFILLER_33_138 VGND VGND VPWR VPWR sky130_fd_sc_hd__fill_2
XFILLER_24_127 VGND VGND VPWR VPWR sky130_fd_sc_hd__fill_2
XFILLER_24_105 VGND VGND VPWR VPWR sky130_fd_sc_hd__decap_3
XFILLER_32_160 VGND VGND VPWR VPWR sky130_fd_sc_hd__decap_3
XFILLER_21_27 VGND VGND VPWR VPWR sky130_fd_sc_hd__fill_2
XFILLER_15_105 VGND VGND VPWR VPWR sky130_fd_sc_hd__decap_3
XFILLER_15_116 VGND VGND VPWR VPWR sky130_fd_sc_hd__decap_3
XFILLER_11_60 VGND VGND VPWR VPWR sky130_fd_sc_hd__decap_3
XTAP_TAPCELL_ROW_16_133 VGND VPWR sky130_fd_sc_hd__tapvpwrvgnd_1
Xinput10 A[18] VGND VGND VPWR VPWR _438_/C sky130_fd_sc_hd__clkdlybuf4s25_1
Xinput21 A[28] VGND VGND VPWR VPWR input21/X sky130_fd_sc_hd__clkdlybuf4s25_1
Xinput32 A[9] VGND VGND VPWR VPWR input32/X sky130_fd_sc_hd__clkdlybuf4s25_1
Xinput43 B[19] VGND VGND VPWR VPWR _449_/B sky130_fd_sc_hd__clkdlybuf4s25_1
Xinput54 B[29] VGND VGND VPWR VPWR _583_/B sky130_fd_sc_hd__clkdlybuf4s25_1
Xinput65 sub VGND VGND VPWR VPWR input65/X sky130_fd_sc_hd__buf_12
XFILLER_12_119 VGND VGND VPWR VPWR sky130_fd_sc_hd__decap_3
XFILLER_32_37 VGND VGND VPWR VPWR sky130_fd_sc_hd__decap_3
XTAP_TAPCELL_ROW_30_180 VGND VPWR sky130_fd_sc_hd__tapvpwrvgnd_1
XFILLER_20_174 VGND VGND VPWR VPWR sky130_fd_sc_hd__decap_3
XTAP_TAPCELL_ROW_7_101 VGND VPWR sky130_fd_sc_hd__tapvpwrvgnd_1
X_671_ _667_/Y _671_/B _671_/C VGND VGND VPWR VPWR _691_/B sky130_fd_sc_hd__nand3b_4
XFILLER_11_163 VGND VGND VPWR VPWR sky130_fd_sc_hd__decap_3
XFILLER_11_185 VGND VGND VPWR VPWR sky130_fd_sc_hd__fill_2
XFILLER_4_115 VGND VGND VPWR VPWR sky130_fd_sc_hd__decap_3
X_654_ _656_/A _655_/B VGND VGND VPWR VPWR _654_/Y sky130_fd_sc_hd__nor2_8
X_723_ _723_/A1 _717_/X _716_/B _716_/A _721_/Y VGND VGND VPWR VPWR _723_/X sky130_fd_sc_hd__o2111a_2
X_585_ _584_/A _584_/B input22/X VGND VGND VPWR VPWR _585_/X sky130_fd_sc_hd__o21ba_2
XFILLER_17_70 VGND VGND VPWR VPWR sky130_fd_sc_hd__fill_1
X_370_ _370_/A _370_/B VGND VGND VPWR VPWR _370_/X sky130_fd_sc_hd__and2_4
X_637_ _716_/Y _637_/B VGND VGND VPWR VPWR _637_/X sky130_fd_sc_hd__xor2_2
X_706_ _704_/B1 _706_/B _706_/C VGND VGND VPWR VPWR _709_/D sky130_fd_sc_hd__nand3b_2
X_568_ _569_/A _569_/B input21/X VGND VGND VPWR VPWR _568_/Y sky130_fd_sc_hd__nor3b_2
X_499_ _499_/A _499_/B VGND VGND VPWR VPWR _499_/X sky130_fd_sc_hd__and2_4
XFILLER_5_62 VGND VGND VPWR VPWR sky130_fd_sc_hd__decap_3
XFILLER_24_38 VGND VGND VPWR VPWR sky130_fd_sc_hd__decap_3
X_422_ _640_/C _684_/Y VGND VGND VPWR VPWR _422_/Y sky130_fd_sc_hd__nand2_4
X_353_ _353_/A _353_/B VGND VGND VPWR VPWR _353_/Y sky130_fd_sc_hd__nand2_2
XFILLER_30_81 VGND VGND VPWR VPWR sky130_fd_sc_hd__decap_3
Xinput8 A[16] VGND VGND VPWR VPWR _657_/C sky130_fd_sc_hd__clkdlybuf4s25_1
XFILLER_10_29 VGND VGND VPWR VPWR sky130_fd_sc_hd__decap_3
XFILLER_27_147 VGND VGND VPWR VPWR sky130_fd_sc_hd__decap_3
XFILLER_27_103 VGND VGND VPWR VPWR sky130_fd_sc_hd__fill_2
XFILLER_35_191 VGND VGND VPWR VPWR sky130_fd_sc_hd__decap_3
XTAP_TAPCELL_ROW_28_175 VGND VPWR sky130_fd_sc_hd__tapvpwrvgnd_1
XFILLER_18_136 VGND VGND VPWR VPWR sky130_fd_sc_hd__decap_3
XFILLER_18_103 VGND VGND VPWR VPWR sky130_fd_sc_hd__decap_3
X_405_ _397_/Y _395_/X _402_/X _418_/A _418_/B VGND VGND VPWR VPWR _410_/D sky130_fd_sc_hd__o2111a_2
XTAP_TAPCELL_ROW_19_142 VGND VPWR sky130_fd_sc_hd__tapvpwrvgnd_1
XFILLER_24_139 VGND VGND VPWR VPWR sky130_fd_sc_hd__fill_1
XFILLER_15_139 VGND VGND VPWR VPWR sky130_fd_sc_hd__decap_3
XFILLER_30_109 VGND VGND VPWR VPWR sky130_fd_sc_hd__decap_3
XFILLER_23_183 VGND VGND VPWR VPWR sky130_fd_sc_hd__decap_3
XFILLER_11_72 VGND VGND VPWR VPWR sky130_fd_sc_hd__decap_3
XFILLER_14_161 VGND VGND VPWR VPWR sky130_fd_sc_hd__fill_2
XTAP_TAPCELL_ROW_16_134 VGND VPWR sky130_fd_sc_hd__tapvpwrvgnd_1
XFILLER_21_109 VGND VGND VPWR VPWR sky130_fd_sc_hd__decap_3
Xinput11 A[19] VGND VGND VPWR VPWR _452_/A sky130_fd_sc_hd__clkdlybuf4s25_1
Xinput22 A[29] VGND VGND VPWR VPWR input22/X sky130_fd_sc_hd__clkdlybuf4s25_1
Xinput33 B[0] VGND VGND VPWR VPWR _616_/S sky130_fd_sc_hd__dlymetal6s4s_1
Xinput44 B[1] VGND VGND VPWR VPWR _382_/B sky130_fd_sc_hd__clkdlybuf4s25_1
Xinput55 B[2] VGND VGND VPWR VPWR _395_/B sky130_fd_sc_hd__clkdlybuf4s25_1
XFILLER_16_39 VGND VGND VPWR VPWR sky130_fd_sc_hd__decap_3
XFILLER_32_49 VGND VGND VPWR VPWR sky130_fd_sc_hd__fill_2
XFILLER_32_27 VGND VGND VPWR VPWR sky130_fd_sc_hd__fill_1
XFILLER_20_153 VGND VGND VPWR VPWR sky130_fd_sc_hd__decap_3
XTAP_TAPCELL_ROW_7_102 VGND VPWR sky130_fd_sc_hd__tapvpwrvgnd_1
XTAP_TAPCELL_ROW_30_181 VGND VPWR sky130_fd_sc_hd__tapvpwrvgnd_1
XFILLER_20_197 VGND VGND VPWR VPWR sky130_fd_sc_hd__decap_3
X_670_ _668_/X _667_/Y _671_/C VGND VGND VPWR VPWR _689_/A sky130_fd_sc_hd__o21bai_4
XFILLER_7_113 VGND VGND VPWR VPWR sky130_fd_sc_hd__decap_3
XFILLER_22_71 VGND VGND VPWR VPWR sky130_fd_sc_hd__decap_3
XFILLER_8_73 VGND VGND VPWR VPWR sky130_fd_sc_hd__decap_3
XFILLER_4_127 VGND VGND VPWR VPWR sky130_fd_sc_hd__decap_3
XFILLER_16_201 VGND VGND VPWR VPWR sky130_fd_sc_hd__decap_3
X_653_ _653_/A VGND VGND VPWR VPWR _653_/Y sky130_fd_sc_hd__inv_2
X_722_ _717_/X _722_/A2 _721_/Y VGND VGND VPWR VPWR _722_/X sky130_fd_sc_hd__o21a_2
X_584_ _584_/A _584_/B input22/X VGND VGND VPWR VPWR _597_/C sky130_fd_sc_hd__or3b_4
XFILLER_17_60 VGND VGND VPWR VPWR sky130_fd_sc_hd__fill_1
XFILLER_3_193 VGND VGND VPWR VPWR sky130_fd_sc_hd__decap_3
XFILLER_0_141 VGND VGND VPWR VPWR sky130_fd_sc_hd__fill_2
X_567_ _569_/A _569_/B input21/X VGND VGND VPWR VPWR _597_/A sky130_fd_sc_hd__o21bai_2
X_636_ _633_/B _708_/X _412_/Y VGND VGND VPWR VPWR _637_/B sky130_fd_sc_hd__a21oi_2
X_705_ _705_/A _705_/B VGND VGND VPWR VPWR _709_/C sky130_fd_sc_hd__nand2_4
X_498_ _499_/A _499_/B VGND VGND VPWR VPWR _498_/Y sky130_fd_sc_hd__nor2_2
XFILLER_5_85 VGND VGND VPWR VPWR sky130_fd_sc_hd__decap_3
XFILLER_5_52 VGND VGND VPWR VPWR sky130_fd_sc_hd__decap_3
X_421_ _421_/A1 _421_/A2 _420_/A _685_/Y VGND VGND VPWR VPWR _423_/C sky130_fd_sc_hd__a31oi_2
X_352_ _356_/A1 _353_/B VGND VGND VPWR VPWR _358_/C sky130_fd_sc_hd__nand2b_2
Xinput9 A[17] VGND VGND VPWR VPWR _429_/C sky130_fd_sc_hd__clkdlybuf4s25_1
X_619_ _385_/Y _390_/Y _416_/Y _410_/C VGND VGND VPWR VPWR _622_/C sky130_fd_sc_hd__a211o_2
XFILLER_27_126 VGND VGND VPWR VPWR sky130_fd_sc_hd__decap_3
XFILLER_18_115 VGND VGND VPWR VPWR sky130_fd_sc_hd__decap_3
X_404_ _399_/X _419_/A2 _418_/B VGND VGND VPWR VPWR _622_/B sky130_fd_sc_hd__o21ai_2
XTAP_TAPCELL_ROW_28_176 VGND VPWR sky130_fd_sc_hd__tapvpwrvgnd_1
XFILLER_26_170 VGND VGND VPWR VPWR sky130_fd_sc_hd__decap_3
XFILLER_25_60 VGND VGND VPWR VPWR sky130_fd_sc_hd__decap_3
XTAP_TAPCELL_ROW_19_143 VGND VPWR sky130_fd_sc_hd__tapvpwrvgnd_1
XPHY_EDGE_ROW_10_Right_10 VGND VGND VPWR VPWR sky130_fd_sc_hd__decap_3
XFILLER_11_51 VGND VGND VPWR VPWR sky130_fd_sc_hd__decap_3
Xinput12 A[1] VGND VGND VPWR VPWR _383_/B sky130_fd_sc_hd__clkdlybuf4s25_1
Xinput23 A[2] VGND VGND VPWR VPWR _397_/B1 sky130_fd_sc_hd__clkdlybuf4s25_1
Xinput34 B[10] VGND VGND VPWR VPWR _712_/B sky130_fd_sc_hd__clkdlybuf4s25_1
Xinput45 B[20] VGND VGND VPWR VPWR _459_/B sky130_fd_sc_hd__clkdlybuf4s25_1
Xinput56 B[30] VGND VGND VPWR VPWR _592_/B sky130_fd_sc_hd__clkdlybuf4s25_1
XFILLER_20_165 VGND VGND VPWR VPWR sky130_fd_sc_hd__decap_3
XTAP_TAPCELL_ROW_30_182 VGND VPWR sky130_fd_sc_hd__tapvpwrvgnd_1
XFILLER_7_169 VGND VGND VPWR VPWR sky130_fd_sc_hd__decap_3
XFILLER_7_147 VGND VGND VPWR VPWR sky130_fd_sc_hd__decap_3
XFILLER_7_136 VGND VGND VPWR VPWR sky130_fd_sc_hd__fill_1
XFILLER_7_103 VGND VGND VPWR VPWR sky130_fd_sc_hd__decap_3
XFILLER_22_94 VGND VGND VPWR VPWR sky130_fd_sc_hd__fill_2
XFILLER_8_85 VGND VGND VPWR VPWR sky130_fd_sc_hd__decap_3
XFILLER_27_39 VGND VGND VPWR VPWR sky130_fd_sc_hd__fill_2
XFILLER_4_106 VGND VGND VPWR VPWR sky130_fd_sc_hd__decap_3
X_583_ _583_/A _583_/B VGND VGND VPWR VPWR _584_/B sky130_fd_sc_hd__and2_2
X_652_ _717_/A VGND VGND VPWR VPWR _727_/A sky130_fd_sc_hd__inv_8
X_721_ _727_/A _717_/B _720_/Y VGND VGND VPWR VPWR _721_/Y sky130_fd_sc_hd__o21ai_4
XPHY_EDGE_ROW_8_Right_8 VGND VGND VPWR VPWR sky130_fd_sc_hd__decap_3
XFILLER_0_153 VGND VGND VPWR VPWR sky130_fd_sc_hd__fill_1
X_704_ _712_/A _702_/B _704_/B1 VGND VGND VPWR VPWR _705_/A sky130_fd_sc_hd__o21a_4
X_566_ _583_/A _566_/B VGND VGND VPWR VPWR _569_/B sky130_fd_sc_hd__and2_2
X_635_ _700_/Y _635_/B VGND VGND VPWR VPWR _635_/Y sky130_fd_sc_hd__xnor2_2
XFILLER_28_93 VGND VGND VPWR VPWR sky130_fd_sc_hd__decap_3
XFILLER_28_71 VGND VGND VPWR VPWR sky130_fd_sc_hd__decap_3
X_497_ _497_/A _497_/B VGND VGND VPWR VPWR _497_/Y sky130_fd_sc_hd__nand2_4
XFILLER_5_97 VGND VGND VPWR VPWR sky130_fd_sc_hd__decap_3
XPHY_EDGE_ROW_17_Left_53 VGND VGND VPWR VPWR sky130_fd_sc_hd__decap_3
XFILLER_24_29 VGND VGND VPWR VPWR sky130_fd_sc_hd__decap_3
XFILLER_6_9 VGND VGND VPWR VPWR sky130_fd_sc_hd__fill_2
X_420_ _420_/A _420_/B _725_/Y VGND VGND VPWR VPWR _640_/C sky130_fd_sc_hd__nand3_4
X_351_ _353_/B _351_/B VGND VGND VPWR VPWR _358_/B sky130_fd_sc_hd__nand2b_4
XFILLER_30_94 VGND VGND VPWR VPWR sky130_fd_sc_hd__decap_3
XFILLER_30_72 VGND VGND VPWR VPWR sky130_fd_sc_hd__decap_3
XFILLER_30_61 VGND VGND VPWR VPWR sky130_fd_sc_hd__fill_2
XFILLER_29_190 VGND VGND VPWR VPWR sky130_fd_sc_hd__decap_3
X_549_ _549_/A _549_/B VGND VGND VPWR VPWR _571_/B sky130_fd_sc_hd__and2_4
X_618_ _390_/Y _385_/Y _384_/Y _410_/C VGND VGND VPWR VPWR _620_/B sky130_fd_sc_hd__a211o_2
XFILLER_27_138 VGND VGND VPWR VPWR sky130_fd_sc_hd__decap_3
XFILLER_27_116 VGND VGND VPWR VPWR sky130_fd_sc_hd__fill_2
XPHY_EDGE_ROW_2_Left_38 VGND VGND VPWR VPWR sky130_fd_sc_hd__decap_3
X_403_ _399_/X _400_/Y _401_/B1 VGND VGND VPWR VPWR _418_/B sky130_fd_sc_hd__o21bai_2
Xrebuffer180 _520_/Y VGND VGND VPWR VPWR _528_/A1 sky130_fd_sc_hd__buf_6
XTAP_TAPCELL_ROW_19_144 VGND VPWR sky130_fd_sc_hd__tapvpwrvgnd_1
XFILLER_24_108 VGND VGND VPWR VPWR sky130_fd_sc_hd__decap_3
XFILLER_32_185 VGND VGND VPWR VPWR sky130_fd_sc_hd__decap_3
XFILLER_32_141 VGND VGND VPWR VPWR sky130_fd_sc_hd__decap_3
XFILLER_15_108 VGND VGND VPWR VPWR sky130_fd_sc_hd__decap_3
XFILLER_15_119 VGND VGND VPWR VPWR sky130_fd_sc_hd__fill_1
XTAP_TAPCELL_ROW_33_191 VGND VPWR sky130_fd_sc_hd__tapvpwrvgnd_1
XFILLER_11_63 VGND VGND VPWR VPWR sky130_fd_sc_hd__decap_3
XFILLER_11_96 VGND VGND VPWR VPWR sky130_fd_sc_hd__decap_3
XFILLER_2_3 VGND VGND VPWR VPWR sky130_fd_sc_hd__fill_1
XFILLER_14_141 VGND VGND VPWR VPWR sky130_fd_sc_hd__decap_3
XFILLER_14_185 VGND VGND VPWR VPWR sky130_fd_sc_hd__decap_3
Xinput13 A[20] VGND VGND VPWR VPWR _460_/B1 sky130_fd_sc_hd__clkdlybuf4s25_1
Xinput24 A[30] VGND VGND VPWR VPWR input24/X sky130_fd_sc_hd__clkdlybuf4s25_1
Xinput35 B[11] VGND VGND VPWR VPWR _717_/B sky130_fd_sc_hd__dlymetal6s4s_1
Xinput46 B[21] VGND VGND VPWR VPWR _473_/B sky130_fd_sc_hd__clkdlybuf4s25_1
Xinput57 B[31] VGND VGND VPWR VPWR _606_/B sky130_fd_sc_hd__clkdlybuf4s25_1
XFILLER_35_3 VGND VGND VPWR VPWR sky130_fd_sc_hd__decap_3
XTAP_TAPCELL_ROW_30_183 VGND VPWR sky130_fd_sc_hd__tapvpwrvgnd_1
XFILLER_32_29 VGND VGND VPWR VPWR sky130_fd_sc_hd__decap_3
XFILLER_20_177 VGND VGND VPWR VPWR sky130_fd_sc_hd__decap_3
XFILLER_28_200 VGND VGND VPWR VPWR sky130_fd_sc_hd__decap_3
XFILLER_11_111 VGND VGND VPWR VPWR sky130_fd_sc_hd__fill_1
XFILLER_11_166 VGND VGND VPWR VPWR sky130_fd_sc_hd__fill_2
XTAP_TAPCELL_ROW_21_150 VGND VPWR sky130_fd_sc_hd__tapvpwrvgnd_1
XPHY_EDGE_ROW_5_Left_41 VGND VGND VPWR VPWR sky130_fd_sc_hd__decap_3
XFILLER_8_53 VGND VGND VPWR VPWR sky130_fd_sc_hd__decap_3
XFILLER_4_118 VGND VGND VPWR VPWR sky130_fd_sc_hd__decap_3
X_720_ _727_/A _717_/B input3/X VGND VGND VPWR VPWR _720_/Y sky130_fd_sc_hd__a21oi_4
XPHY_EDGE_ROW_31_Left_67 VGND VGND VPWR VPWR sky130_fd_sc_hd__decap_3
X_582_ _583_/A _583_/B VGND VGND VPWR VPWR _584_/A sky130_fd_sc_hd__nor2_2
X_651_ _607_/A _607_/B _613_/X _610_/Y VGND VGND VPWR VPWR _651_/Y sky130_fd_sc_hd__o2bb2ai_4
XFILLER_17_95 VGND VGND VPWR VPWR sky130_fd_sc_hd__decap_3
XFILLER_33_94 VGND VGND VPWR VPWR sky130_fd_sc_hd__decap_3
XFILLER_3_184 VGND VGND VPWR VPWR sky130_fd_sc_hd__decap_3
XFILLER_0_132 VGND VGND VPWR VPWR sky130_fd_sc_hd__decap_3
X_634_ _705_/A _705_/B _633_/B _709_/D VGND VGND VPWR VPWR _635_/B sky130_fd_sc_hd__a22o_2
X_703_ _702_/B _712_/A VGND VGND VPWR VPWR _706_/C sky130_fd_sc_hd__nand2b_4
X_565_ _565_/A _566_/B VGND VGND VPWR VPWR _569_/A sky130_fd_sc_hd__nor2_2
X_496_ _496_/A _496_/B VGND VGND VPWR VPWR _497_/B sky130_fd_sc_hd__nand2_2
XFILLER_5_65 VGND VGND VPWR VPWR sky130_fd_sc_hd__fill_1
XFILLER_24_19 VGND VGND VPWR VPWR sky130_fd_sc_hd__decap_3
X_350_ _728_/X _730_/Y _729_/Y VGND VGND VPWR VPWR _629_/A sky130_fd_sc_hd__o21ai_2
XFILLER_14_85 VGND VGND VPWR VPWR sky130_fd_sc_hd__decap_3
XFILLER_30_40 VGND VGND VPWR VPWR sky130_fd_sc_hd__decap_3
X_617_ _617_/A _617_/B VGND VGND VPWR VPWR _617_/Y sky130_fd_sc_hd__xnor2_2
XPHY_EDGE_ROW_34_Left_70 VGND VGND VPWR VPWR sky130_fd_sc_hd__decap_3
X_548_ _547_/A _547_/B input19/X VGND VGND VPWR VPWR _549_/B sky130_fd_sc_hd__o21bai_2
X_479_ _471_/A _507_/A _458_/X _460_/Y VGND VGND VPWR VPWR _479_/Y sky130_fd_sc_hd__o2bb2ai_2
XFILLER_35_29 VGND VGND VPWR VPWR sky130_fd_sc_hd__decap_3
XFILLER_35_194 VGND VGND VPWR VPWR sky130_fd_sc_hd__fill_2
XFILLER_35_172 VGND VGND VPWR VPWR sky130_fd_sc_hd__fill_2
XFILLER_35_150 VGND VGND VPWR VPWR sky130_fd_sc_hd__decap_3
XFILLER_18_139 VGND VGND VPWR VPWR sky130_fd_sc_hd__fill_1
XFILLER_18_106 VGND VGND VPWR VPWR sky130_fd_sc_hd__decap_3
X_402_ _717_/A _400_/B _401_/Y VGND VGND VPWR VPWR _402_/X sky130_fd_sc_hd__a21o_2
XFILLER_26_150 VGND VGND VPWR VPWR sky130_fd_sc_hd__decap_3
XFILLER_2_66 VGND VGND VPWR VPWR sky130_fd_sc_hd__decap_3
XFILLER_2_22 VGND VGND VPWR VPWR sky130_fd_sc_hd__fill_2
XFILLER_17_183 VGND VGND VPWR VPWR sky130_fd_sc_hd__decap_3
XFILLER_17_172 VGND VGND VPWR VPWR sky130_fd_sc_hd__fill_2
XFILLER_32_197 VGND VGND VPWR VPWR sky130_fd_sc_hd__decap_3
XFILLER_23_186 VGND VGND VPWR VPWR sky130_fd_sc_hd__decap_3
XFILLER_11_42 VGND VGND VPWR VPWR sky130_fd_sc_hd__decap_3
XFILLER_11_75 VGND VGND VPWR VPWR sky130_fd_sc_hd__decap_3
XTAP_TAPCELL_ROW_33_192 VGND VPWR sky130_fd_sc_hd__tapvpwrvgnd_1
Xinput14 A[21] VGND VGND VPWR VPWR _476_/B1 sky130_fd_sc_hd__clkdlybuf4s25_1
Xinput25 A[31] VGND VGND VPWR VPWR _607_/A sky130_fd_sc_hd__clkdlybuf4s25_1
Xinput36 B[12] VGND VGND VPWR VPWR _673_/B sky130_fd_sc_hd__clkdlybuf4s25_1
Xinput47 B[22] VGND VGND VPWR VPWR _490_/B sky130_fd_sc_hd__clkdlybuf4s25_1
Xinput58 B[3] VGND VGND VPWR VPWR _400_/B sky130_fd_sc_hd__clkdlybuf4s25_1
XFILLER_20_112 VGND VGND VPWR VPWR sky130_fd_sc_hd__decap_3
XFILLER_20_156 VGND VGND VPWR VPWR sky130_fd_sc_hd__decap_3
XTAP_TAPCELL_ROW_21_151 VGND VPWR sky130_fd_sc_hd__tapvpwrvgnd_1
XFILLER_7_116 VGND VGND VPWR VPWR sky130_fd_sc_hd__decap_3
XFILLER_22_52 VGND VGND VPWR VPWR sky130_fd_sc_hd__decap_3
XFILLER_22_85 VGND VGND VPWR VPWR sky130_fd_sc_hd__decap_3
XFILLER_22_74 VGND VGND VPWR VPWR sky130_fd_sc_hd__fill_1
XFILLER_8_76 VGND VGND VPWR VPWR sky130_fd_sc_hd__decap_3
XFILLER_25_204 VGND VGND VPWR VPWR sky130_fd_sc_hd__decap_3
X_650_ _650_/A _650_/B VGND VGND VPWR VPWR _650_/Y sky130_fd_sc_hd__nor2_4
XFILLER_16_204 VGND VGND VPWR VPWR sky130_fd_sc_hd__decap_3
X_581_ _579_/Y _581_/B VGND VGND VPWR VPWR _581_/X sky130_fd_sc_hd__and2b_4
XFILLER_33_73 VGND VGND VPWR VPWR sky130_fd_sc_hd__fill_1
XFILLER_3_196 VGND VGND VPWR VPWR sky130_fd_sc_hd__decap_3
X_633_ _707_/Y _633_/B VGND VGND VPWR VPWR _633_/Y sky130_fd_sc_hd__xnor2_2
X_702_ _727_/A _702_/B VGND VGND VPWR VPWR _706_/B sky130_fd_sc_hd__nand2_2
XFILLER_28_62 VGND VGND VPWR VPWR sky130_fd_sc_hd__decap_3
X_564_ _559_/Y _563_/Y _562_/Y VGND VGND VPWR VPWR _564_/Y sky130_fd_sc_hd__o21ai_2
X_495_ _495_/A1 _506_/A _486_/Y _496_/B VGND VGND VPWR VPWR _497_/A sky130_fd_sc_hd__a211o_4
XFILLER_8_200 VGND VGND VPWR VPWR sky130_fd_sc_hd__fill_2
XFILLER_5_55 VGND VGND VPWR VPWR sky130_fd_sc_hd__fill_1
XFILLER_5_88 VGND VGND VPWR VPWR sky130_fd_sc_hd__decap_3
XFILLER_30_52 VGND VGND VPWR VPWR sky130_fd_sc_hd__decap_3
XFILLER_30_85 VGND VGND VPWR VPWR sky130_fd_sc_hd__decap_3
X_547_ _547_/A _547_/B input19/X VGND VGND VPWR VPWR _549_/A sky130_fd_sc_hd__or3b_4
X_616_ _616_/A0 _615_/A _616_/S VGND VGND VPWR VPWR _617_/A sky130_fd_sc_hd__mux2_1
XFILLER_29_181 VGND VGND VPWR VPWR sky130_fd_sc_hd__decap_3
X_478_ _473_/X _476_/Y _475_/Y VGND VGND VPWR VPWR _515_/C sky130_fd_sc_hd__o21ai_2
XFILLER_27_129 VGND VGND VPWR VPWR sky130_fd_sc_hd__decap_3
X_401_ _370_/A _400_/B _401_/B1 VGND VGND VPWR VPWR _401_/Y sky130_fd_sc_hd__o21ai_4
XFILLER_26_173 VGND VGND VPWR VPWR sky130_fd_sc_hd__decap_3
XFILLER_18_118 VGND VGND VPWR VPWR sky130_fd_sc_hd__decap_3
XFILLER_25_74 VGND VGND VPWR VPWR sky130_fd_sc_hd__decap_3
XFILLER_25_63 VGND VGND VPWR VPWR sky130_fd_sc_hd__fill_1
Xrebuffer160 _640_/D VGND VGND VPWR VPWR _423_/A sky130_fd_sc_hd__buf_2
XFILLER_17_195 VGND VGND VPWR VPWR sky130_fd_sc_hd__fill_2
XTAP_TAPCELL_ROW_33_193 VGND VPWR sky130_fd_sc_hd__tapvpwrvgnd_1
XFILLER_23_154 VGND VGND VPWR VPWR sky130_fd_sc_hd__decap_3
XFILLER_23_132 VGND VGND VPWR VPWR sky130_fd_sc_hd__fill_2
XFILLER_23_110 VGND VGND VPWR VPWR sky130_fd_sc_hd__fill_2
XFILLER_11_54 VGND VGND VPWR VPWR sky130_fd_sc_hd__fill_2
Xinput15 A[22] VGND VGND VPWR VPWR _491_/C sky130_fd_sc_hd__clkdlybuf4s25_1
Xinput26 A[3] VGND VGND VPWR VPWR _401_/B1 sky130_fd_sc_hd__clkdlybuf4s25_1
Xinput37 B[13] VGND VGND VPWR VPWR _669_/B sky130_fd_sc_hd__clkdlybuf4s25_1
Xinput48 B[23] VGND VGND VPWR VPWR _499_/B sky130_fd_sc_hd__clkdlybuf4s25_1
Xinput59 B[4] VGND VGND VPWR VPWR _362_/B sky130_fd_sc_hd__clkdlybuf4s25_1
XTAP_TAPCELL_ROW_24_160 VGND VPWR sky130_fd_sc_hd__tapvpwrvgnd_1
XFILLER_20_168 VGND VGND VPWR VPWR sky130_fd_sc_hd__decap_3
XFILLER_11_102 VGND VGND VPWR VPWR sky130_fd_sc_hd__decap_3
XFILLER_11_135 VGND VGND VPWR VPWR sky130_fd_sc_hd__decap_3
XFILLER_7_106 VGND VGND VPWR VPWR sky130_fd_sc_hd__decap_3
XFILLER_8_33 VGND VGND VPWR VPWR sky130_fd_sc_hd__decap_3
XFILLER_8_11 VGND VGND VPWR VPWR sky130_fd_sc_hd__decap_3
XFILLER_8_88 VGND VGND VPWR VPWR sky130_fd_sc_hd__decap_3
XFILLER_6_194 VGND VGND VPWR VPWR sky130_fd_sc_hd__fill_2
XTAP_TAPCELL_ROW_35_200 VGND VPWR sky130_fd_sc_hd__tapvpwrvgnd_1
XFILLER_4_109 VGND VGND VPWR VPWR sky130_fd_sc_hd__decap_3
X_580_ _597_/A _597_/B _605_/A VGND VGND VPWR VPWR _581_/B sky130_fd_sc_hd__a21o_2
XTAP_TAPCELL_ROW_4_89 VGND VPWR sky130_fd_sc_hd__tapvpwrvgnd_1
XFILLER_3_153 VGND VGND VPWR VPWR sky130_fd_sc_hd__decap_3
XPHY_EDGE_ROW_17_Right_17 VGND VGND VPWR VPWR sky130_fd_sc_hd__decap_3
XPHY_EDGE_ROW_26_Right_26 VGND VGND VPWR VPWR sky130_fd_sc_hd__decap_3
X_563_ _563_/A _571_/C VGND VGND VPWR VPWR _563_/Y sky130_fd_sc_hd__nand2_2
X_632_ _411_/C _411_/A _378_/X _625_/B VGND VGND VPWR VPWR _633_/B sky130_fd_sc_hd__o2bb2ai_2
X_701_ _701_/A _702_/B VGND VGND VPWR VPWR _705_/B sky130_fd_sc_hd__nand2_2
XFILLER_28_96 VGND VGND VPWR VPWR sky130_fd_sc_hd__decap_3
XFILLER_28_74 VGND VGND VPWR VPWR sky130_fd_sc_hd__decap_3
X_494_ _506_/B _506_/C VGND VGND VPWR VPWR _496_/B sky130_fd_sc_hd__nand2_2
XPHY_EDGE_ROW_35_Right_35 VGND VGND VPWR VPWR sky130_fd_sc_hd__decap_3
XFILLER_30_97 VGND VGND VPWR VPWR sky130_fd_sc_hd__decap_3
XFILLER_30_75 VGND VGND VPWR VPWR sky130_fd_sc_hd__decap_3
XFILLER_30_20 VGND VGND VPWR VPWR sky130_fd_sc_hd__decap_3
XTAP_TAPCELL_ROW_1_79 VGND VPWR sky130_fd_sc_hd__tapvpwrvgnd_1
X_546_ _546_/A _546_/B VGND VGND VPWR VPWR _547_/B sky130_fd_sc_hd__and2_2
X_615_ _615_/A _616_/S VGND VGND VPWR VPWR _615_/X sky130_fd_sc_hd__xor2_2
XFILLER_29_193 VGND VGND VPWR VPWR sky130_fd_sc_hd__fill_2
X_477_ _473_/A _473_/B _476_/Y VGND VGND VPWR VPWR _477_/Y sky130_fd_sc_hd__a21oi_2
X_400_ _400_/A _400_/B VGND VGND VPWR VPWR _400_/Y sky130_fd_sc_hd__nor2_2
XFILLER_26_141 VGND VGND VPWR VPWR sky130_fd_sc_hd__decap_3
XFILLER_25_42 VGND VGND VPWR VPWR sky130_fd_sc_hd__decap_3
XFILLER_25_20 VGND VGND VPWR VPWR sky130_fd_sc_hd__decap_3
Xrebuffer172 _616_/A0 VGND VGND VPWR VPWR fanout104/A sky130_fd_sc_hd__buf_4
Xrebuffer161 _648_/D VGND VGND VPWR VPWR _649_/B1 sky130_fd_sc_hd__buf_2
X_529_ _520_/Y _559_/A2 _558_/A VGND VGND VPWR VPWR _538_/B sky130_fd_sc_hd__a21o_2
XFILLER_32_144 VGND VGND VPWR VPWR sky130_fd_sc_hd__decap_3
XFILLER_11_66 VGND VGND VPWR VPWR sky130_fd_sc_hd__decap_3
XFILLER_11_99 VGND VGND VPWR VPWR sky130_fd_sc_hd__decap_3
XFILLER_14_144 VGND VGND VPWR VPWR sky130_fd_sc_hd__fill_2
XFILLER_14_155 VGND VGND VPWR VPWR sky130_fd_sc_hd__decap_3
XFILLER_14_188 VGND VGND VPWR VPWR sky130_fd_sc_hd__fill_1
XTAP_TAPCELL_ROW_24_161 VGND VPWR sky130_fd_sc_hd__tapvpwrvgnd_1
Xinput16 A[23] VGND VGND VPWR VPWR _502_/B1 sky130_fd_sc_hd__clkdlybuf4s25_1
Xinput27 A[4] VGND VGND VPWR VPWR _364_/B1 sky130_fd_sc_hd__clkdlybuf4s25_1
Xinput38 B[14] VGND VGND VPWR VPWR _664_/B sky130_fd_sc_hd__clkdlybuf4s25_1
Xinput49 B[24] VGND VGND VPWR VPWR _523_/B sky130_fd_sc_hd__clkdlybuf4s25_1
XFILLER_35_6 VGND VGND VPWR VPWR sky130_fd_sc_hd__fill_1
XFILLER_20_103 VGND VGND VPWR VPWR sky130_fd_sc_hd__decap_3
XFILLER_22_21 VGND VGND VPWR VPWR sky130_fd_sc_hd__decap_3
XFILLER_0_3 VGND VGND VPWR VPWR sky130_fd_sc_hd__decap_3
XFILLER_34_206 VGND VGND VPWR VPWR sky130_fd_sc_hd__decap_3
XTAP_TAPCELL_ROW_12_120 VGND VPWR sky130_fd_sc_hd__tapvpwrvgnd_1
XFILLER_8_56 VGND VGND VPWR VPWR sky130_fd_sc_hd__decap_3
XTAP_TAPCELL_ROW_35_201 VGND VPWR sky130_fd_sc_hd__tapvpwrvgnd_1
XPHY_EDGE_ROW_9_Left_45 VGND VGND VPWR VPWR sky130_fd_sc_hd__decap_3
XFILLER_17_32 VGND VGND VPWR VPWR sky130_fd_sc_hd__decap_3
XFILLER_17_98 VGND VGND VPWR VPWR sky130_fd_sc_hd__decap_3
XFILLER_33_97 VGND VGND VPWR VPWR sky130_fd_sc_hd__fill_2
XFILLER_3_187 VGND VGND VPWR VPWR sky130_fd_sc_hd__decap_3
XFILLER_0_135 VGND VGND VPWR VPWR sky130_fd_sc_hd__decap_3
X_700_ _709_/B _709_/A VGND VGND VPWR VPWR _700_/Y sky130_fd_sc_hd__nand2_2
XFILLER_28_20 VGND VGND VPWR VPWR sky130_fd_sc_hd__fill_1
X_562_ _559_/Y _561_/Y _571_/C VGND VGND VPWR VPWR _562_/Y sky130_fd_sc_hd__o21bai_2
X_631_ _631_/A _631_/B VGND VGND VPWR VPWR _631_/X sky130_fd_sc_hd__xor2_2
X_493_ _488_/Y _489_/X _491_/C VGND VGND VPWR VPWR _506_/C sky130_fd_sc_hd__o21bai_4
XFILLER_28_53 VGND VGND VPWR VPWR sky130_fd_sc_hd__decap_3
XFILLER_28_42 VGND VGND VPWR VPWR sky130_fd_sc_hd__decap_3
XFILLER_5_57 VGND VGND VPWR VPWR sky130_fd_sc_hd__fill_1
XFILLER_5_46 VGND VGND VPWR VPWR sky130_fd_sc_hd__decap_3
XFILLER_14_88 VGND VGND VPWR VPWR sky130_fd_sc_hd__fill_1
XFILLER_30_43 VGND VGND VPWR VPWR sky130_fd_sc_hd__decap_3
XFILLER_30_32 VGND VGND VPWR VPWR sky130_fd_sc_hd__decap_3
XFILLER_29_172 VGND VGND VPWR VPWR sky130_fd_sc_hd__decap_3
X_545_ _545_/A _546_/B VGND VGND VPWR VPWR _547_/A sky130_fd_sc_hd__nor2_2
X_614_ _605_/Y _609_/X _611_/Y _612_/Y VGND VGND VPWR VPWR _614_/Y sky130_fd_sc_hd__a22oi_4
X_476_ _473_/A _473_/B _476_/B1 VGND VGND VPWR VPWR _476_/Y sky130_fd_sc_hd__o21ai_2
XFILLER_35_153 VGND VGND VPWR VPWR sky130_fd_sc_hd__decap_3
XFILLER_35_197 VGND VGND VPWR VPWR sky130_fd_sc_hd__decap_3
XFILLER_18_109 VGND VGND VPWR VPWR sky130_fd_sc_hd__decap_3
XFILLER_26_153 VGND VGND VPWR VPWR sky130_fd_sc_hd__fill_1
Xrebuffer173 _673_/A VGND VGND VPWR VPWR _675_/A1 sky130_fd_sc_hd__buf_2
Xrebuffer140 _370_/A VGND VGND VPWR VPWR _373_/A1 sky130_fd_sc_hd__buf_2
XPHY_EDGE_ROW_22_Left_58 VGND VGND VPWR VPWR sky130_fd_sc_hd__decap_3
XFILLER_2_69 VGND VGND VPWR VPWR sky130_fd_sc_hd__decap_3
X_528_ _528_/A1 _559_/A2 _558_/A VGND VGND VPWR VPWR _528_/Y sky130_fd_sc_hd__a21oi_4
X_459_ _459_/A _459_/B VGND VGND VPWR VPWR _459_/Y sky130_fd_sc_hd__nor2_2
XTAP_TAPCELL_ROW_27_170 VGND VPWR sky130_fd_sc_hd__tapvpwrvgnd_1
XFILLER_17_186 VGND VGND VPWR VPWR sky130_fd_sc_hd__fill_2
XFILLER_23_101 VGND VGND VPWR VPWR sky130_fd_sc_hd__decap_3
XFILLER_11_45 VGND VGND VPWR VPWR sky130_fd_sc_hd__decap_3
XFILLER_11_78 VGND VGND VPWR VPWR sky130_fd_sc_hd__decap_3
XTAP_TAPCELL_ROW_24_162 VGND VPWR sky130_fd_sc_hd__tapvpwrvgnd_1
Xinput17 A[24] VGND VGND VPWR VPWR _525_/C sky130_fd_sc_hd__clkdlybuf4s25_1
Xinput28 A[5] VGND VGND VPWR VPWR _653_/A sky130_fd_sc_hd__clkdlybuf4s25_1
Xinput39 B[15] VGND VGND VPWR VPWR _661_/B sky130_fd_sc_hd__clkdlybuf4s25_1
XFILLER_9_182 VGND VGND VPWR VPWR sky130_fd_sc_hd__decap_3
XFILLER_20_159 VGND VGND VPWR VPWR sky130_fd_sc_hd__decap_3
XFILLER_7_119 VGND VGND VPWR VPWR sky130_fd_sc_hd__fill_2
XFILLER_22_88 VGND VGND VPWR VPWR sky130_fd_sc_hd__decap_3
XFILLER_22_55 VGND VGND VPWR VPWR sky130_fd_sc_hd__fill_1
XFILLER_8_79 VGND VGND VPWR VPWR sky130_fd_sc_hd__decap_3
XFILLER_10_181 VGND VGND VPWR VPWR sky130_fd_sc_hd__fill_1
XFILLER_10_192 VGND VGND VPWR VPWR sky130_fd_sc_hd__decap_3
XPHY_EDGE_ROW_25_Left_61 VGND VGND VPWR VPWR sky130_fd_sc_hd__decap_3
XTAP_TAPCELL_ROW_35_202 VGND VPWR sky130_fd_sc_hd__tapvpwrvgnd_1
XFILLER_25_207 VGND VGND VPWR VPWR sky130_fd_sc_hd__decap_3
XFILLER_16_207 VGND VGND VPWR VPWR sky130_fd_sc_hd__decap_3
XFILLER_17_55 VGND VGND VPWR VPWR sky130_fd_sc_hd__fill_1
XFILLER_3_166 VGND VGND VPWR VPWR sky130_fd_sc_hd__fill_2
XFILLER_3_122 VGND VGND VPWR VPWR sky130_fd_sc_hd__decap_3
XFILLER_3_199 VGND VGND VPWR VPWR sky130_fd_sc_hd__fill_2
XPHY_EDGE_ROW_3_Right_3 VGND VGND VPWR VPWR sky130_fd_sc_hd__decap_3
X_630_ _729_/Y _407_/Y _378_/A _630_/B2 VGND VGND VPWR VPWR _631_/B sky130_fd_sc_hd__o2bb2a_2
XFILLER_28_65 VGND VGND VPWR VPWR sky130_fd_sc_hd__decap_3
XFILLER_28_32 VGND VGND VPWR VPWR sky130_fd_sc_hd__decap_3
X_561_ _563_/A VGND VGND VPWR VPWR _561_/Y sky130_fd_sc_hd__inv_2
X_492_ _488_/Y _489_/X _491_/C VGND VGND VPWR VPWR _492_/X sky130_fd_sc_hd__o21ba_2
XFILLER_14_78 VGND VGND VPWR VPWR sky130_fd_sc_hd__decap_3
XFILLER_30_88 VGND VGND VPWR VPWR sky130_fd_sc_hd__decap_3
XFILLER_30_55 VGND VGND VPWR VPWR sky130_fd_sc_hd__decap_3
X_613_ _613_/A _613_/B VGND VGND VPWR VPWR _613_/X sky130_fd_sc_hd__or2_2
XFILLER_29_184 VGND VGND VPWR VPWR sky130_fd_sc_hd__decap_3
X_544_ _544_/A VGND VGND VPWR VPWR _551_/B sky130_fd_sc_hd__inv_2
X_475_ _472_/Y _473_/X _476_/B1 VGND VGND VPWR VPWR _475_/Y sky130_fd_sc_hd__o21bai_4
XFILLER_2_209 VGND VGND VPWR VPWR sky130_fd_sc_hd__fill_2
XFILLER_26_121 VGND VGND VPWR VPWR sky130_fd_sc_hd__decap_3
XFILLER_26_176 VGND VGND VPWR VPWR sky130_fd_sc_hd__decap_3
XFILLER_25_77 VGND VGND VPWR VPWR sky130_fd_sc_hd__fill_2
XFILLER_25_55 VGND VGND VPWR VPWR sky130_fd_sc_hd__fill_1
Xrebuffer141 _418_/A VGND VGND VPWR VPWR _622_/A sky130_fd_sc_hd__buf_2
Xrebuffer130 _725_/Y VGND VGND VPWR VPWR _421_/A1 sky130_fd_sc_hd__buf_2
XFILLER_17_110 VGND VGND VPWR VPWR sky130_fd_sc_hd__fill_2
X_527_ _538_/C _527_/B VGND VGND VPWR VPWR _558_/A sky130_fd_sc_hd__nand2_2
X_458_ _459_/A _459_/B VGND VGND VPWR VPWR _458_/X sky130_fd_sc_hd__and2_4
X_389_ _379_/B _616_/S _615_/A VGND VGND VPWR VPWR _389_/Y sky130_fd_sc_hd__o21ai_2
XTAP_TAPCELL_ROW_27_171 VGND VPWR sky130_fd_sc_hd__tapvpwrvgnd_1
XFILLER_32_157 VGND VGND VPWR VPWR sky130_fd_sc_hd__decap_3
XFILLER_23_157 VGND VGND VPWR VPWR sky130_fd_sc_hd__fill_2
XFILLER_23_113 VGND VGND VPWR VPWR sky130_fd_sc_hd__decap_3
XFILLER_11_57 VGND VGND VPWR VPWR sky130_fd_sc_hd__decap_3
Xinput18 A[25] VGND VGND VPWR VPWR _535_/B1 sky130_fd_sc_hd__clkdlybuf4s25_1
XFILLER_22_190 VGND VGND VPWR VPWR sky130_fd_sc_hd__decap_3
Xinput29 A[6] VGND VGND VPWR VPWR _730_/B1 sky130_fd_sc_hd__clkdlybuf4s25_1
XTAP_TAPCELL_ROW_15_130 VGND VPWR sky130_fd_sc_hd__tapvpwrvgnd_1
XFILLER_3_91 VGND VGND VPWR VPWR sky130_fd_sc_hd__decap_3
XFILLER_11_105 VGND VGND VPWR VPWR sky130_fd_sc_hd__decap_3
XFILLER_7_109 VGND VGND VPWR VPWR sky130_fd_sc_hd__decap_3
XFILLER_8_36 VGND VGND VPWR VPWR sky130_fd_sc_hd__decap_3
XFILLER_8_14 VGND VGND VPWR VPWR sky130_fd_sc_hd__fill_1
XFILLER_6_131 VGND VGND VPWR VPWR sky130_fd_sc_hd__fill_2
XFILLER_6_197 VGND VGND VPWR VPWR sky130_fd_sc_hd__decap_3
XTAP_TAPCELL_ROW_35_203 VGND VPWR sky130_fd_sc_hd__tapvpwrvgnd_1
XFILLER_19_3 VGND VGND VPWR VPWR sky130_fd_sc_hd__fill_2
XFILLER_17_12 VGND VGND VPWR VPWR sky130_fd_sc_hd__fill_2
XFILLER_3_156 VGND VGND VPWR VPWR sky130_fd_sc_hd__fill_2
XFILLER_3_145 VGND VGND VPWR VPWR sky130_fd_sc_hd__fill_1
X_560_ _549_/B _544_/A _549_/A VGND VGND VPWR VPWR _560_/Y sky130_fd_sc_hd__a21boi_2
XFILLER_28_99 VGND VGND VPWR VPWR sky130_fd_sc_hd__fill_1
XFILLER_28_77 VGND VGND VPWR VPWR sky130_fd_sc_hd__fill_2
X_491_ _488_/Y _491_/B _491_/C VGND VGND VPWR VPWR _491_/Y sky130_fd_sc_hd__nand3b_4
XFILLER_5_26 VGND VGND VPWR VPWR sky130_fd_sc_hd__decap_3
XFILLER_5_15 VGND VGND VPWR VPWR sky130_fd_sc_hd__decap_3
X_689_ _689_/A _691_/B VGND VGND VPWR VPWR _689_/Y sky130_fd_sc_hd__nand2_2
XPHY_EDGE_ROW_13_Right_13 VGND VGND VPWR VPWR sky130_fd_sc_hd__decap_3
XPHY_EDGE_ROW_22_Right_22 VGND VGND VPWR VPWR sky130_fd_sc_hd__decap_3
XPHY_EDGE_ROW_31_Right_31 VGND VGND VPWR VPWR sky130_fd_sc_hd__decap_3
XFILLER_14_46 VGND VGND VPWR VPWR sky130_fd_sc_hd__decap_3
XFILLER_30_23 VGND VGND VPWR VPWR sky130_fd_sc_hd__decap_3
XFILLER_30_78 VGND VGND VPWR VPWR sky130_fd_sc_hd__decap_3
X_543_ _538_/C _536_/X _534_/X VGND VGND VPWR VPWR _544_/A sky130_fd_sc_hd__a21oi_2
X_612_ _613_/A _613_/B VGND VGND VPWR VPWR _612_/Y sky130_fd_sc_hd__nor2_2
XFILLER_29_152 VGND VGND VPWR VPWR sky130_fd_sc_hd__decap_3
X_474_ _472_/Y _473_/X _476_/B1 VGND VGND VPWR VPWR _474_/X sky130_fd_sc_hd__o21ba_2
XFILLER_6_91 VGND VGND VPWR VPWR sky130_fd_sc_hd__fill_1
XFILLER_26_144 VGND VGND VPWR VPWR sky130_fd_sc_hd__decap_3
XFILLER_26_133 VGND VGND VPWR VPWR sky130_fd_sc_hd__decap_3
XFILLER_26_100 VGND VGND VPWR VPWR sky130_fd_sc_hd__fill_1
XFILLER_26_188 VGND VGND VPWR VPWR sky130_fd_sc_hd__fill_1
XFILLER_25_45 VGND VGND VPWR VPWR sky130_fd_sc_hd__fill_1
XFILLER_25_23 VGND VGND VPWR VPWR sky130_fd_sc_hd__decap_3
Xrebuffer164 _491_/Y VGND VGND VPWR VPWR _506_/B sky130_fd_sc_hd__buf_2
Xrebuffer142 _363_/B VGND VGND VPWR VPWR _353_/A sky130_fd_sc_hd__buf_4
Xrebuffer131 _376_/B VGND VGND VPWR VPWR _411_/C sky130_fd_sc_hd__buf_2
X_526_ _521_/Y _522_/X _525_/C VGND VGND VPWR VPWR _527_/B sky130_fd_sc_hd__o21bai_2
XTAP_TAPCELL_ROW_27_172 VGND VPWR sky130_fd_sc_hd__tapvpwrvgnd_1
XFILLER_32_147 VGND VGND VPWR VPWR sky130_fd_sc_hd__fill_2
XFILLER_17_166 VGND VGND VPWR VPWR sky130_fd_sc_hd__fill_2
XFILLER_17_122 VGND VGND VPWR VPWR sky130_fd_sc_hd__decap_3
X_457_ _457_/A _457_/B VGND VGND VPWR VPWR _457_/Y sky130_fd_sc_hd__nand2_2
X_388_ _583_/A _616_/S VGND VGND VPWR VPWR _388_/Y sky130_fd_sc_hd__nor2_2
XFILLER_11_69 VGND VGND VPWR VPWR sky130_fd_sc_hd__decap_3
XFILLER_31_180 VGND VGND VPWR VPWR sky130_fd_sc_hd__fill_2
XFILLER_14_158 VGND VGND VPWR VPWR sky130_fd_sc_hd__decap_3
Xinput19 A[26] VGND VGND VPWR VPWR input19/X sky130_fd_sc_hd__clkdlybuf4s25_1
X_509_ _492_/X _486_/A _506_/B VGND VGND VPWR VPWR _509_/Y sky130_fd_sc_hd__o21ai_2
XFILLER_20_106 VGND VGND VPWR VPWR sky130_fd_sc_hd__decap_3
XFILLER_9_162 VGND VGND VPWR VPWR sky130_fd_sc_hd__decap_3
XFILLER_22_24 VGND VGND VPWR VPWR sky130_fd_sc_hd__decap_3
XFILLER_0_6 VGND VGND VPWR VPWR sky130_fd_sc_hd__decap_3
XFILLER_34_209 VGND VGND VPWR VPWR sky130_fd_sc_hd__fill_2
XTAP_TAPCELL_ROW_35_204 VGND VPWR sky130_fd_sc_hd__tapvpwrvgnd_1
XFILLER_17_57 VGND VGND VPWR VPWR sky130_fd_sc_hd__decap_3
XFILLER_17_35 VGND VGND VPWR VPWR sky130_fd_sc_hd__decap_3
XFILLER_3_113 VGND VGND VPWR VPWR sky130_fd_sc_hd__decap_3
XFILLER_31_3 VGND VGND VPWR VPWR sky130_fd_sc_hd__decap_3
XFILLER_0_138 VGND VGND VPWR VPWR sky130_fd_sc_hd__fill_2
XFILLER_28_56 VGND VGND VPWR VPWR sky130_fd_sc_hd__decap_3
XFILLER_28_45 VGND VGND VPWR VPWR sky130_fd_sc_hd__fill_1
X_490_ _499_/A _490_/B VGND VGND VPWR VPWR _491_/B sky130_fd_sc_hd__nand2_2
XFILLER_5_49 VGND VGND VPWR VPWR sky130_fd_sc_hd__decap_3
X_688_ _665_/A _666_/Y _680_/Y VGND VGND VPWR VPWR _688_/X sky130_fd_sc_hd__o21a_2
XFILLER_30_46 VGND VGND VPWR VPWR sky130_fd_sc_hd__fill_1
X_542_ _559_/A2 _520_/Y _571_/A VGND VGND VPWR VPWR _542_/Y sky130_fd_sc_hd__a21boi_2
X_611_ _611_/A _611_/B VGND VGND VPWR VPWR _611_/Y sky130_fd_sc_hd__nand2_2
X_473_ _473_/A _473_/B VGND VGND VPWR VPWR _473_/X sky130_fd_sc_hd__and2_4
XFILLER_29_175 VGND VGND VPWR VPWR sky130_fd_sc_hd__decap_3
XFILLER_29_131 VGND VGND VPWR VPWR sky130_fd_sc_hd__decap_3
XFILLER_26_112 VGND VGND VPWR VPWR sky130_fd_sc_hd__decap_3
Xrebuffer132 _689_/A VGND VGND VPWR VPWR _691_/C sky130_fd_sc_hd__buf_4
XFILLER_25_57 VGND VGND VPWR VPWR sky130_fd_sc_hd__decap_3
Xrebuffer165 _546_/A VGND VGND VPWR VPWR _545_/A sky130_fd_sc_hd__buf_2
Xrebuffer143 _573_/A VGND VGND VPWR VPWR _530_/A2 sky130_fd_sc_hd__buf_2
XFILLER_17_101 VGND VGND VPWR VPWR sky130_fd_sc_hd__decap_3
X_525_ _521_/Y _525_/B _525_/C VGND VGND VPWR VPWR _538_/C sky130_fd_sc_hd__nand3b_2
X_456_ _456_/A _466_/B _456_/C _466_/A VGND VGND VPWR VPWR _457_/B sky130_fd_sc_hd__nand4_2
X_387_ _565_/A _616_/S VGND VGND VPWR VPWR _387_/X sky130_fd_sc_hd__and2_4
XTAP_TAPCELL_ROW_2_82 VGND VPWR sky130_fd_sc_hd__tapvpwrvgnd_1
XTAP_TAPCELL_ROW_18_140 VGND VPWR sky130_fd_sc_hd__tapvpwrvgnd_1
XFILLER_23_104 VGND VGND VPWR VPWR sky130_fd_sc_hd__decap_3
XFILLER_11_48 VGND VGND VPWR VPWR sky130_fd_sc_hd__decap_3
X_508_ _515_/A _477_/Y _506_/C _475_/Y VGND VGND VPWR VPWR _508_/Y sky130_fd_sc_hd__o211ai_2
X_439_ _437_/A _437_/B _438_/C VGND VGND VPWR VPWR _440_/B sky130_fd_sc_hd__o21bai_4
XFILLER_9_185 VGND VGND VPWR VPWR sky130_fd_sc_hd__decap_3
XFILLER_10_195 VGND VGND VPWR VPWR sky130_fd_sc_hd__fill_1
XFILLER_33_57 VGND VGND VPWR VPWR sky130_fd_sc_hd__fill_2
XFILLER_3_125 VGND VGND VPWR VPWR sky130_fd_sc_hd__decap_3
XFILLER_3_169 VGND VGND VPWR VPWR sky130_fd_sc_hd__decap_3
XPHY_EDGE_ROW_29_Left_65 VGND VGND VPWR VPWR sky130_fd_sc_hd__decap_3
XPHY_EDGE_ROW_13_Left_49 VGND VGND VPWR VPWR sky130_fd_sc_hd__decap_3
XFILLER_24_3 VGND VGND VPWR VPWR sky130_fd_sc_hd__fill_1
XFILLER_21_202 VGND VGND VPWR VPWR sky130_fd_sc_hd__fill_1
XFILLER_28_68 VGND VGND VPWR VPWR sky130_fd_sc_hd__decap_3
XFILLER_28_35 VGND VGND VPWR VPWR sky130_fd_sc_hd__decap_3
X_687_ _674_/B _675_/Y _686_/Y VGND VGND VPWR VPWR _692_/A sky130_fd_sc_hd__o21a_2
XTAP_TAPCELL_ROW_5_93 VGND VPWR sky130_fd_sc_hd__tapvpwrvgnd_1
Xload_slew120 _473_/A VGND VGND VPWR VPWR _459_/A sky130_fd_sc_hd__buf_6
XPHY_EDGE_ROW_7_Right_7 VGND VGND VPWR VPWR sky130_fd_sc_hd__decap_3
XFILLER_30_58 VGND VGND VPWR VPWR sky130_fd_sc_hd__decap_3
X_610_ _605_/A _605_/D _611_/B VGND VGND VPWR VPWR _610_/Y sky130_fd_sc_hd__a21boi_2
XFILLER_29_143 VGND VGND VPWR VPWR sky130_fd_sc_hd__decap_3
X_541_ _558_/A _558_/B VGND VGND VPWR VPWR _571_/A sky130_fd_sc_hd__nor2_4
X_472_ _473_/A _473_/B VGND VGND VPWR VPWR _472_/Y sky130_fd_sc_hd__nor2_2
XFILLER_29_187 VGND VGND VPWR VPWR sky130_fd_sc_hd__decap_3
XFILLER_20_91 VGND VGND VPWR VPWR sky130_fd_sc_hd__decap_3
XFILLER_35_113 VGND VGND VPWR VPWR sky130_fd_sc_hd__decap_3
XPHY_EDGE_ROW_16_Left_52 VGND VGND VPWR VPWR sky130_fd_sc_hd__decap_3
XFILLER_26_179 VGND VGND VPWR VPWR sky130_fd_sc_hd__fill_2
XFILLER_26_124 VGND VGND VPWR VPWR sky130_fd_sc_hd__fill_2
XFILLER_25_36 VGND VGND VPWR VPWR sky130_fd_sc_hd__decap_3
Xrebuffer144 fanout111/A VGND VGND VPWR VPWR _712_/A sky130_fd_sc_hd__buf_4
Xrebuffer133 _415_/A VGND VGND VPWR VPWR _640_/A sky130_fd_sc_hd__buf_6
Xrebuffer122 _507_/A VGND VGND VPWR VPWR _471_/B sky130_fd_sc_hd__buf_6
Xrebuffer166 _560_/Y VGND VGND VPWR VPWR _563_/A sky130_fd_sc_hd__buf_2
XFILLER_17_113 VGND VGND VPWR VPWR sky130_fd_sc_hd__decap_3
XFILLER_15_91 VGND VGND VPWR VPWR sky130_fd_sc_hd__decap_3
X_524_ _521_/Y _525_/B _525_/C VGND VGND VPWR VPWR _524_/X sky130_fd_sc_hd__and3b_2
X_455_ _466_/B _456_/C _456_/A _466_/A VGND VGND VPWR VPWR _457_/A sky130_fd_sc_hd__a22o_2
X_386_ _384_/A _384_/B _385_/Y VGND VGND VPWR VPWR _617_/B sky130_fd_sc_hd__o21ai_4
XFILLER_32_116 VGND VGND VPWR VPWR sky130_fd_sc_hd__decap_3
XFILLER_31_90 VGND VGND VPWR VPWR sky130_fd_sc_hd__decap_3
Xoutput90 _614_/Y VGND VGND VPWR VPWR S[31] sky130_fd_sc_hd__buf_6
XTAP_TAPCELL_ROW_2_83 VGND VPWR sky130_fd_sc_hd__tapvpwrvgnd_1
XTAP_TAPCELL_ROW_18_141 VGND VPWR sky130_fd_sc_hd__tapvpwrvgnd_1
XFILLER_23_116 VGND VGND VPWR VPWR sky130_fd_sc_hd__fill_1
XFILLER_31_160 VGND VGND VPWR VPWR sky130_fd_sc_hd__fill_1
XPHY_EDGE_ROW_1_Left_37 VGND VGND VPWR VPWR sky130_fd_sc_hd__decap_3
XFILLER_22_160 VGND VGND VPWR VPWR sky130_fd_sc_hd__decap_3
XFILLER_22_193 VGND VGND VPWR VPWR sky130_fd_sc_hd__decap_3
XFILLER_13_160 VGND VGND VPWR VPWR sky130_fd_sc_hd__decap_3
XFILLER_13_182 VGND VGND VPWR VPWR sky130_fd_sc_hd__decap_3
X_507_ _507_/A _507_/B VGND VGND VPWR VPWR _507_/Y sky130_fd_sc_hd__nand2_4
X_438_ _437_/A _438_/B _438_/C VGND VGND VPWR VPWR _440_/A sky130_fd_sc_hd__nand3b_2
X_369_ _370_/A _370_/B VGND VGND VPWR VPWR _369_/Y sky130_fd_sc_hd__nor2_2
XFILLER_9_197 VGND VGND VPWR VPWR sky130_fd_sc_hd__fill_1
XFILLER_3_94 VGND VGND VPWR VPWR sky130_fd_sc_hd__decap_3
XFILLER_11_108 VGND VGND VPWR VPWR sky130_fd_sc_hd__decap_3
XFILLER_10_141 VGND VGND VPWR VPWR sky130_fd_sc_hd__decap_3
XFILLER_33_25 VGND VGND VPWR VPWR sky130_fd_sc_hd__decap_3
XPHY_EDGE_ROW_4_Left_40 VGND VGND VPWR VPWR sky130_fd_sc_hd__decap_3
XFILLER_23_80 VGND VGND VPWR VPWR sky130_fd_sc_hd__decap_3
XFILLER_0_129 VGND VGND VPWR VPWR sky130_fd_sc_hd__decap_3
XPHY_EDGE_ROW_30_Left_66 VGND VGND VPWR VPWR sky130_fd_sc_hd__decap_3
XFILLER_5_18 VGND VGND VPWR VPWR sky130_fd_sc_hd__fill_1
X_686_ _674_/A _674_/B _677_/C VGND VGND VPWR VPWR _686_/Y sky130_fd_sc_hd__o21bai_2
XFILLER_18_91 VGND VGND VPWR VPWR sky130_fd_sc_hd__decap_3
XTAP_TAPCELL_ROW_5_94 VGND VPWR sky130_fd_sc_hd__tapvpwrvgnd_1
Xload_slew110 _606_/A VGND VGND VPWR VPWR _565_/A sky130_fd_sc_hd__buf_6
XFILLER_14_27 VGND VGND VPWR VPWR sky130_fd_sc_hd__fill_1
XFILLER_14_49 VGND VGND VPWR VPWR sky130_fd_sc_hd__decap_3
XFILLER_30_26 VGND VGND VPWR VPWR sky130_fd_sc_hd__fill_2
X_540_ _540_/A _540_/B VGND VGND VPWR VPWR _540_/Y sky130_fd_sc_hd__nand2_2
XFILLER_29_155 VGND VGND VPWR VPWR sky130_fd_sc_hd__decap_3
XFILLER_29_122 VGND VGND VPWR VPWR sky130_fd_sc_hd__decap_3
X_471_ _471_/A _471_/B VGND VGND VPWR VPWR _471_/X sky130_fd_sc_hd__xor2_4
XFILLER_20_81 VGND VGND VPWR VPWR sky130_fd_sc_hd__decap_3
X_669_ _673_/A _669_/B VGND VGND VPWR VPWR _671_/B sky130_fd_sc_hd__nand2_2
XFILLER_35_169 VGND VGND VPWR VPWR sky130_fd_sc_hd__decap_3
XFILLER_35_136 VGND VGND VPWR VPWR sky130_fd_sc_hd__decap_3
XFILLER_26_147 VGND VGND VPWR VPWR sky130_fd_sc_hd__decap_3
XFILLER_26_136 VGND VGND VPWR VPWR sky130_fd_sc_hd__decap_3
XFILLER_25_26 VGND VGND VPWR VPWR sky130_fd_sc_hd__decap_3
Xrebuffer167 _573_/Y VGND VGND VPWR VPWR _578_/A3 sky130_fd_sc_hd__buf_2
Xrebuffer145 fanout111/A VGND VGND VPWR VPWR _701_/A sky130_fd_sc_hd__buf_2
Xrebuffer134 _365_/Y VGND VGND VPWR VPWR _406_/B sky130_fd_sc_hd__buf_2
Xrebuffer123 _507_/A VGND VGND VPWR VPWR _511_/A1 sky130_fd_sc_hd__buf_6
X_523_ _546_/A _523_/B VGND VGND VPWR VPWR _525_/B sky130_fd_sc_hd__nand2_2
XFILLER_17_169 VGND VGND VPWR VPWR sky130_fd_sc_hd__decap_3
XFILLER_17_125 VGND VGND VPWR VPWR sky130_fd_sc_hd__fill_2
X_454_ _466_/B _456_/C VGND VGND VPWR VPWR _464_/D sky130_fd_sc_hd__nand2_2
X_385_ _383_/B _385_/B _385_/C VGND VGND VPWR VPWR _385_/Y sky130_fd_sc_hd__nand3b_4
XFILLER_32_139 VGND VGND VPWR VPWR sky130_fd_sc_hd__fill_1
XTAP_TAPCELL_ROW_2_84 VGND VPWR sky130_fd_sc_hd__tapvpwrvgnd_1
XFILLER_31_80 VGND VGND VPWR VPWR sky130_fd_sc_hd__decap_3
Xoutput91 _623_/Y VGND VGND VPWR VPWR S[3] sky130_fd_sc_hd__buf_6
Xoutput80 _497_/Y VGND VGND VPWR VPWR S[22] sky130_fd_sc_hd__buf_8
XFILLER_14_106 VGND VGND VPWR VPWR sky130_fd_sc_hd__fill_1
XFILLER_14_139 VGND VGND VPWR VPWR sky130_fd_sc_hd__fill_1
X_506_ _506_/A _506_/B _506_/C VGND VGND VPWR VPWR _507_/B sky130_fd_sc_hd__and3_2
XFILLER_26_91 VGND VGND VPWR VPWR sky130_fd_sc_hd__decap_3
X_437_ _437_/A _437_/B VGND VGND VPWR VPWR _437_/Y sky130_fd_sc_hd__nor2_2
X_368_ _361_/X _626_/A2 _376_/C VGND VGND VPWR VPWR _625_/A sky130_fd_sc_hd__o21a_2
XFILLER_9_165 VGND VGND VPWR VPWR sky130_fd_sc_hd__decap_3
XFILLER_20_109 VGND VGND VPWR VPWR sky130_fd_sc_hd__decap_3
XFILLER_22_27 VGND VGND VPWR VPWR sky130_fd_sc_hd__fill_1
XFILLER_0_9 VGND VGND VPWR VPWR sky130_fd_sc_hd__decap_3
Xfanout100 _381_/A VGND VGND VPWR VPWR _356_/A1 sky130_fd_sc_hd__buf_8
Xfanout111 fanout111/A VGND VGND VPWR VPWR _695_/A sky130_fd_sc_hd__buf_6
XPHY_EDGE_ROW_29_Right_29 VGND VGND VPWR VPWR sky130_fd_sc_hd__decap_3
XFILLER_12_82 VGND VGND VPWR VPWR sky130_fd_sc_hd__fill_2
XFILLER_24_201 VGND VGND VPWR VPWR sky130_fd_sc_hd__fill_2
XFILLER_17_38 VGND VGND VPWR VPWR sky130_fd_sc_hd__fill_2
XFILLER_33_37 VGND VGND VPWR VPWR sky130_fd_sc_hd__decap_3
XFILLER_3_116 VGND VGND VPWR VPWR sky130_fd_sc_hd__decap_3
XFILLER_23_92 VGND VGND VPWR VPWR sky130_fd_sc_hd__decap_3
XFILLER_31_6 VGND VGND VPWR VPWR sky130_fd_sc_hd__fill_1
XFILLER_2_193 VGND VGND VPWR VPWR sky130_fd_sc_hd__decap_3
XFILLER_0_85 VGND VGND VPWR VPWR sky130_fd_sc_hd__fill_1
XFILLER_9_50 VGND VGND VPWR VPWR sky130_fd_sc_hd__fill_2
XFILLER_28_59 VGND VGND VPWR VPWR sky130_fd_sc_hd__decap_3
X_685_ _683_/Y _678_/Y _692_/C VGND VGND VPWR VPWR _685_/Y sky130_fd_sc_hd__o21ai_4
XTAP_TAPCELL_ROW_5_95 VGND VPWR sky130_fd_sc_hd__tapvpwrvgnd_1
XFILLER_29_178 VGND VGND VPWR VPWR sky130_fd_sc_hd__decap_3
XFILLER_29_101 VGND VGND VPWR VPWR sky130_fd_sc_hd__fill_2
X_470_ _452_/Y _466_/X _424_/Y _465_/Y VGND VGND VPWR VPWR _507_/A sky130_fd_sc_hd__o22ai_4
X_599_ _605_/A _605_/D VGND VGND VPWR VPWR _611_/A sky130_fd_sc_hd__nand2_2
X_668_ _673_/A _669_/B VGND VGND VPWR VPWR _668_/X sky130_fd_sc_hd__and2_4
XFILLER_26_115 VGND VGND VPWR VPWR sky130_fd_sc_hd__decap_3
XFILLER_34_192 VGND VGND VPWR VPWR sky130_fd_sc_hd__decap_3
Xrebuffer146 input65/X VGND VGND VPWR VPWR _656_/B sky130_fd_sc_hd__buf_2
Xrebuffer135 fanout104/A VGND VGND VPWR VPWR _717_/A sky130_fd_sc_hd__buf_4
Xrebuffer124 _507_/A VGND VGND VPWR VPWR _495_/A1 sky130_fd_sc_hd__buf_6
XFILLER_17_104 VGND VGND VPWR VPWR sky130_fd_sc_hd__decap_3
X_522_ _546_/A _523_/B VGND VGND VPWR VPWR _522_/X sky130_fd_sc_hd__and2_2
X_453_ _450_/A _450_/B _452_/A VGND VGND VPWR VPWR _456_/C sky130_fd_sc_hd__o21bai_4
XFILLER_17_148 VGND VGND VPWR VPWR sky130_fd_sc_hd__decap_3
XFILLER_15_60 VGND VGND VPWR VPWR sky130_fd_sc_hd__fill_1
XFILLER_15_82 VGND VGND VPWR VPWR sky130_fd_sc_hd__decap_3
X_384_ _384_/A _384_/B VGND VGND VPWR VPWR _384_/Y sky130_fd_sc_hd__nor2_2
XFILLER_25_181 VGND VGND VPWR VPWR sky130_fd_sc_hd__decap_3
Xoutput70 _644_/Y VGND VGND VPWR VPWR S[13] sky130_fd_sc_hd__buf_6
XTAP_TAPCELL_ROW_2_85 VGND VPWR sky130_fd_sc_hd__tapvpwrvgnd_1
Xoutput92 _625_/Y VGND VGND VPWR VPWR S[4] sky130_fd_sc_hd__buf_6
Xoutput81 _513_/Y VGND VGND VPWR VPWR S[23] sky130_fd_sc_hd__buf_6
XFILLER_16_181 VGND VGND VPWR VPWR sky130_fd_sc_hd__decap_3
XFILLER_31_140 VGND VGND VPWR VPWR sky130_fd_sc_hd__fill_2
XFILLER_23_107 VGND VGND VPWR VPWR sky130_fd_sc_hd__decap_3
XTAP_TAPCELL_ROW_32_190 VGND VPWR sky130_fd_sc_hd__tapvpwrvgnd_1
XFILLER_13_140 VGND VGND VPWR VPWR sky130_fd_sc_hd__decap_3
X_505_ _499_/X _502_/Y _501_/Y VGND VGND VPWR VPWR _505_/Y sky130_fd_sc_hd__o21ai_2
X_436_ _436_/A _436_/B VGND VGND VPWR VPWR _438_/B sky130_fd_sc_hd__nand2_2
XFILLER_26_81 VGND VGND VPWR VPWR sky130_fd_sc_hd__decap_3
X_367_ _364_/B1 _367_/B _367_/C VGND VGND VPWR VPWR _376_/C sky130_fd_sc_hd__nand3b_2
XFILLER_9_122 VGND VGND VPWR VPWR sky130_fd_sc_hd__decap_3
XFILLER_3_52 VGND VGND VPWR VPWR sky130_fd_sc_hd__decap_3
XTAP_TAPCELL_ROW_21_149 VGND VPWR sky130_fd_sc_hd__tapvpwrvgnd_1
XFILLER_12_50 VGND VGND VPWR VPWR sky130_fd_sc_hd__decap_3
X_419_ _399_/X _419_/A2 _418_/Y _417_/Y VGND VGND VPWR VPWR _420_/A sky130_fd_sc_hd__o22ai_4
XFILLER_23_71 VGND VGND VPWR VPWR sky130_fd_sc_hd__decap_3
XFILLER_28_38 VGND VGND VPWR VPWR sky130_fd_sc_hd__fill_1
X_684_ _679_/Y _682_/X _692_/C VGND VGND VPWR VPWR _684_/Y sky130_fd_sc_hd__a21boi_2
XFILLER_18_82 VGND VGND VPWR VPWR sky130_fd_sc_hd__fill_2
Xload_slew112 _695_/A VGND VGND VPWR VPWR _673_/A sky130_fd_sc_hd__buf_8
Xload_slew101 _356_/A1 VGND VGND VPWR VPWR _363_/B sky130_fd_sc_hd__buf_8
XFILLER_29_146 VGND VGND VPWR VPWR sky130_fd_sc_hd__decap_3
XFILLER_29_113 VGND VGND VPWR VPWR sky130_fd_sc_hd__decap_3
XFILLER_20_94 VGND VGND VPWR VPWR sky130_fd_sc_hd__fill_1
XFILLER_20_72 VGND VGND VPWR VPWR sky130_fd_sc_hd__decap_3
XFILLER_29_70 VGND VGND VPWR VPWR sky130_fd_sc_hd__decap_3
X_598_ _577_/A _577_/B _605_/D VGND VGND VPWR VPWR _598_/Y sky130_fd_sc_hd__a21boi_2
X_667_ _673_/A _669_/B VGND VGND VPWR VPWR _667_/Y sky130_fd_sc_hd__nor2_4
XFILLER_35_116 VGND VGND VPWR VPWR sky130_fd_sc_hd__decap_3
XFILLER_6_41 VGND VGND VPWR VPWR sky130_fd_sc_hd__decap_3
XFILLER_6_85 VGND VGND VPWR VPWR sky130_fd_sc_hd__decap_3
XFILLER_6_74 VGND VGND VPWR VPWR sky130_fd_sc_hd__fill_1
XFILLER_25_39 VGND VGND VPWR VPWR sky130_fd_sc_hd__decap_3
Xrebuffer147 fanout102/X VGND VGND VPWR VPWR _379_/B sky130_fd_sc_hd__buf_2
Xrebuffer136 _723_/A1 VGND VGND VPWR VPWR _722_/A2 sky130_fd_sc_hd__buf_2
Xrebuffer125 _420_/B VGND VGND VPWR VPWR _421_/A2 sky130_fd_sc_hd__buf_2
X_521_ _546_/A _523_/B VGND VGND VPWR VPWR _521_/Y sky130_fd_sc_hd__nor2_2
X_452_ _452_/A _452_/B VGND VGND VPWR VPWR _452_/Y sky130_fd_sc_hd__nor2_2
X_383_ _383_/A _383_/B VGND VGND VPWR VPWR _384_/B sky130_fd_sc_hd__nand2_2
XFILLER_32_119 VGND VGND VPWR VPWR sky130_fd_sc_hd__decap_3
XFILLER_17_116 VGND VGND VPWR VPWR sky130_fd_sc_hd__decap_3
Xoutput93 _627_/Y VGND VGND VPWR VPWR S[5] sky130_fd_sc_hd__buf_4
Xoutput82 _531_/X VGND VGND VPWR VPWR S[24] sky130_fd_sc_hd__buf_6
Xoutput71 _647_/X VGND VGND VPWR VPWR S[14] sky130_fd_sc_hd__buf_6
XFILLER_31_93 VGND VGND VPWR VPWR sky130_fd_sc_hd__decap_3
X_719_ _717_/A _717_/B _718_/Y VGND VGND VPWR VPWR _719_/Y sky130_fd_sc_hd__a21oi_2
XFILLER_31_152 VGND VGND VPWR VPWR sky130_fd_sc_hd__fill_1
XFILLER_22_174 VGND VGND VPWR VPWR sky130_fd_sc_hd__decap_3
XFILLER_22_163 VGND VGND VPWR VPWR sky130_fd_sc_hd__decap_3
XFILLER_22_141 VGND VGND VPWR VPWR sky130_fd_sc_hd__decap_3
XFILLER_13_163 VGND VGND VPWR VPWR sky130_fd_sc_hd__decap_3
XFILLER_13_185 VGND VGND VPWR VPWR sky130_fd_sc_hd__decap_3
X_504_ _499_/X _502_/Y _501_/Y VGND VGND VPWR VPWR _504_/X sky130_fd_sc_hd__o21a_2
X_435_ _436_/A _436_/B VGND VGND VPWR VPWR _437_/B sky130_fd_sc_hd__and2_4
X_366_ _364_/B1 _367_/B _367_/C VGND VGND VPWR VPWR _366_/X sky130_fd_sc_hd__and3b_2
XFILLER_3_97 VGND VGND VPWR VPWR sky130_fd_sc_hd__fill_1
XFILLER_22_18 VGND VGND VPWR VPWR sky130_fd_sc_hd__decap_3
Xfanout102 _616_/A0 VGND VGND VPWR VPWR fanout102/X sky130_fd_sc_hd__buf_8
Xfanout113 fanout114/X VGND VGND VPWR VPWR _664_/A sky130_fd_sc_hd__clkbuf_2
XTAP_TAPCELL_ROW_12_117 VGND VPWR sky130_fd_sc_hd__tapvpwrvgnd_1
XFILLER_10_111 VGND VGND VPWR VPWR sky130_fd_sc_hd__decap_3
XFILLER_10_144 VGND VGND VPWR VPWR sky130_fd_sc_hd__decap_3
XFILLER_12_62 VGND VGND VPWR VPWR sky130_fd_sc_hd__fill_1
X_418_ _418_/A _418_/B VGND VGND VPWR VPWR _418_/Y sky130_fd_sc_hd__nand2_2
X_349_ _353_/A _728_/B _730_/Y VGND VGND VPWR VPWR _406_/D sky130_fd_sc_hd__a21o_4
XFILLER_33_28 VGND VGND VPWR VPWR sky130_fd_sc_hd__fill_1
XFILLER_23_50 VGND VGND VPWR VPWR sky130_fd_sc_hd__decap_3
XFILLER_23_83 VGND VGND VPWR VPWR sky130_fd_sc_hd__decap_3
XFILLER_0_21 VGND VGND VPWR VPWR sky130_fd_sc_hd__decap_3
XFILLER_12_206 VGND VGND VPWR VPWR sky130_fd_sc_hd__decap_3
XPHY_EDGE_ROW_8_Left_44 VGND VGND VPWR VPWR sky130_fd_sc_hd__decap_3
X_683_ input6/X _665_/Y _692_/B VGND VGND VPWR VPWR _683_/Y sky130_fd_sc_hd__o21ai_2
XFILLER_18_94 VGND VGND VPWR VPWR sky130_fd_sc_hd__decap_3
XFILLER_30_29 VGND VGND VPWR VPWR sky130_fd_sc_hd__decap_3
XFILLER_29_125 VGND VGND VPWR VPWR sky130_fd_sc_hd__decap_3
XFILLER_29_169 VGND VGND VPWR VPWR sky130_fd_sc_hd__decap_3
XFILLER_29_158 VGND VGND VPWR VPWR sky130_fd_sc_hd__fill_1
XFILLER_29_60 VGND VGND VPWR VPWR sky130_fd_sc_hd__decap_3
X_597_ _597_/A _597_/B _597_/C _597_/D VGND VGND VPWR VPWR _605_/D sky130_fd_sc_hd__and4_4
X_666_ _664_/A _664_/B input6/X VGND VGND VPWR VPWR _666_/Y sky130_fd_sc_hd__o21ai_2
XFILLER_35_139 VGND VGND VPWR VPWR sky130_fd_sc_hd__fill_1
XFILLER_28_191 VGND VGND VPWR VPWR sky130_fd_sc_hd__decap_3
XFILLER_34_161 VGND VGND VPWR VPWR sky130_fd_sc_hd__decap_3
XFILLER_26_139 VGND VGND VPWR VPWR sky130_fd_sc_hd__fill_1
XFILLER_26_106 VGND VGND VPWR VPWR sky130_fd_sc_hd__decap_3
Xrebuffer137 _718_/Y VGND VGND VPWR VPWR _723_/A1 sky130_fd_sc_hd__buf_2
Xrebuffer126 _424_/Y VGND VGND VPWR VPWR _425_/B sky130_fd_sc_hd__buf_2
Xrebuffer159 _641_/A VGND VGND VPWR VPWR _642_/B sky130_fd_sc_hd__buf_2
Xrebuffer148 _356_/A1 VGND VGND VPWR VPWR _351_/B sky130_fd_sc_hd__buf_2
X_520_ _692_/X _685_/Y _422_/Y _415_/Y _518_/X VGND VGND VPWR VPWR _520_/Y sky130_fd_sc_hd__o221ai_4
XFILLER_15_51 VGND VGND VPWR VPWR sky130_fd_sc_hd__decap_3
XFILLER_15_73 VGND VGND VPWR VPWR sky130_fd_sc_hd__decap_3
X_451_ _452_/B _452_/A VGND VGND VPWR VPWR _466_/B sky130_fd_sc_hd__nand2_2
X_382_ _382_/A _382_/B VGND VGND VPWR VPWR _384_/A sky130_fd_sc_hd__nor2_4
XFILLER_25_172 VGND VGND VPWR VPWR sky130_fd_sc_hd__decap_3
Xoutput94 _629_/Y VGND VGND VPWR VPWR S[6] sky130_fd_sc_hd__buf_6
Xoutput83 _540_/Y VGND VGND VPWR VPWR S[25] sky130_fd_sc_hd__buf_6
Xoutput72 _650_/Y VGND VGND VPWR VPWR S[15] sky130_fd_sc_hd__buf_6
XFILLER_16_150 VGND VGND VPWR VPWR sky130_fd_sc_hd__decap_3
X_649_ _692_/C _692_/B _649_/B1 _680_/Y VGND VGND VPWR VPWR _650_/B sky130_fd_sc_hd__a22oi_2
X_718_ _717_/B _370_/A input3/X VGND VGND VPWR VPWR _718_/Y sky130_fd_sc_hd__o21ai_4
XFILLER_16_172 VGND VGND VPWR VPWR sky130_fd_sc_hd__decap_3
XFILLER_31_186 VGND VGND VPWR VPWR sky130_fd_sc_hd__fill_1
XTAP_TAPCELL_ROW_24_159 VGND VPWR sky130_fd_sc_hd__tapvpwrvgnd_1
X_503_ _499_/A _499_/B _502_/Y VGND VGND VPWR VPWR _503_/X sky130_fd_sc_hd__a21o_2
XFILLER_13_131 VGND VGND VPWR VPWR sky130_fd_sc_hd__decap_3
X_434_ _436_/A _436_/B VGND VGND VPWR VPWR _437_/A sky130_fd_sc_hd__nor2_4
X_365_ _353_/A _362_/B _364_/Y VGND VGND VPWR VPWR _365_/Y sky130_fd_sc_hd__a21oi_4
XPHY_EDGE_ROW_21_Left_57 VGND VGND VPWR VPWR sky130_fd_sc_hd__decap_3
XFILLER_9_113 VGND VGND VPWR VPWR sky130_fd_sc_hd__decap_3
XFILLER_26_94 VGND VGND VPWR VPWR sky130_fd_sc_hd__decap_3
XFILLER_9_179 VGND VGND VPWR VPWR sky130_fd_sc_hd__decap_3
XFILLER_3_21 VGND VGND VPWR VPWR sky130_fd_sc_hd__fill_2
Xfanout114 input65/X VGND VGND VPWR VPWR fanout114/X sky130_fd_sc_hd__buf_6
XFILLER_10_134 VGND VGND VPWR VPWR sky130_fd_sc_hd__decap_3
XTAP_TAPCELL_ROW_12_118 VGND VPWR sky130_fd_sc_hd__tapvpwrvgnd_1
XFILLER_10_156 VGND VGND VPWR VPWR sky130_fd_sc_hd__decap_3
XFILLER_10_178 VGND VGND VPWR VPWR sky130_fd_sc_hd__decap_3
XFILLER_12_85 VGND VGND VPWR VPWR sky130_fd_sc_hd__decap_3
XFILLER_6_105 VGND VGND VPWR VPWR sky130_fd_sc_hd__fill_2
XPHY_EDGE_ROW_16_Right_16 VGND VGND VPWR VPWR sky130_fd_sc_hd__decap_3
X_417_ _385_/Y _390_/Y _416_/Y VGND VGND VPWR VPWR _417_/Y sky130_fd_sc_hd__a21oi_2
XPHY_EDGE_ROW_25_Right_25 VGND VGND VPWR VPWR sky130_fd_sc_hd__decap_3
XPHY_EDGE_ROW_34_Right_34 VGND VGND VPWR VPWR sky130_fd_sc_hd__decap_3
XFILLER_3_119 VGND VGND VPWR VPWR sky130_fd_sc_hd__decap_3
XFILLER_23_95 VGND VGND VPWR VPWR sky130_fd_sc_hd__decap_3
XFILLER_2_141 VGND VGND VPWR VPWR sky130_fd_sc_hd__decap_3
XPHY_EDGE_ROW_24_Left_60 VGND VGND VPWR VPWR sky130_fd_sc_hd__decap_3
XFILLER_9_86 VGND VGND VPWR VPWR sky130_fd_sc_hd__decap_3
XFILLER_28_29 VGND VGND VPWR VPWR sky130_fd_sc_hd__decap_3
X_682_ input6/X _665_/Y _692_/B VGND VGND VPWR VPWR _682_/X sky130_fd_sc_hd__o21a_2
XFILLER_18_62 VGND VGND VPWR VPWR sky130_fd_sc_hd__fill_2
Xload_slew103 fanout102/X VGND VGND VPWR VPWR _381_/A sky130_fd_sc_hd__buf_8
XPHY_EDGE_ROW_2_Right_2 VGND VGND VPWR VPWR sky130_fd_sc_hd__decap_3
XFILLER_20_85 VGND VGND VPWR VPWR sky130_fd_sc_hd__decap_3
XFILLER_20_52 VGND VGND VPWR VPWR sky130_fd_sc_hd__decap_3
X_665_ _665_/A _665_/B VGND VGND VPWR VPWR _665_/Y sky130_fd_sc_hd__nor2_2
XFILLER_29_50 VGND VGND VPWR VPWR sky130_fd_sc_hd__decap_3
X_596_ _605_/B _605_/C VGND VGND VPWR VPWR _596_/Y sky130_fd_sc_hd__nand2_2
XFILLER_26_118 VGND VGND VPWR VPWR sky130_fd_sc_hd__decap_3
Xrebuffer138 _381_/A VGND VGND VPWR VPWR _382_/A sky130_fd_sc_hd__buf_2
Xrebuffer127 _691_/B VGND VGND VPWR VPWR _645_/B1 sky130_fd_sc_hd__buf_2
XFILLER_34_195 VGND VGND VPWR VPWR sky130_fd_sc_hd__fill_1
XFILLER_17_107 VGND VGND VPWR VPWR sky130_fd_sc_hd__decap_3
XFILLER_15_85 VGND VGND VPWR VPWR sky130_fd_sc_hd__decap_3
X_450_ _450_/A _450_/B VGND VGND VPWR VPWR _452_/B sky130_fd_sc_hd__nor2_2
X_381_ _381_/A _382_/B VGND VGND VPWR VPWR _383_/A sky130_fd_sc_hd__nand2_2
XFILLER_25_184 VGND VGND VPWR VPWR sky130_fd_sc_hd__decap_3
XFILLER_25_162 VGND VGND VPWR VPWR sky130_fd_sc_hd__decap_3
Xoutput95 _631_/X VGND VGND VPWR VPWR S[7] sky130_fd_sc_hd__buf_4
Xoutput84 _552_/Y VGND VGND VPWR VPWR S[26] sky130_fd_sc_hd__buf_6
Xoutput73 _425_/X VGND VGND VPWR VPWR S[16] sky130_fd_sc_hd__buf_4
XFILLER_16_184 VGND VGND VPWR VPWR sky130_fd_sc_hd__decap_3
X_648_ _692_/C _680_/Y _692_/B _648_/D VGND VGND VPWR VPWR _650_/A sky130_fd_sc_hd__and4_2
X_717_ _717_/A _717_/B VGND VGND VPWR VPWR _717_/X sky130_fd_sc_hd__and2_2
XFILLER_16_195 VGND VGND VPWR VPWR sky130_fd_sc_hd__fill_1
X_579_ _577_/B _577_/A _570_/Y VGND VGND VPWR VPWR _579_/Y sky130_fd_sc_hd__a21oi_2
XFILLER_31_132 VGND VGND VPWR VPWR sky130_fd_sc_hd__fill_1
XFILLER_22_132 VGND VGND VPWR VPWR sky130_fd_sc_hd__decap_3
XFILLER_22_187 VGND VGND VPWR VPWR sky130_fd_sc_hd__decap_3
X_502_ _499_/A _499_/B _502_/B1 VGND VGND VPWR VPWR _502_/Y sky130_fd_sc_hd__o21ai_2
X_433_ _464_/B _433_/B VGND VGND VPWR VPWR _433_/X sky130_fd_sc_hd__xor2_2
XFILLER_26_62 VGND VGND VPWR VPWR sky130_fd_sc_hd__decap_3
XFILLER_13_143 VGND VGND VPWR VPWR sky130_fd_sc_hd__fill_2
XFILLER_13_154 VGND VGND VPWR VPWR sky130_fd_sc_hd__decap_3
XFILLER_13_176 VGND VGND VPWR VPWR sky130_fd_sc_hd__decap_3
X_364_ _362_/B _363_/B _364_/B1 VGND VGND VPWR VPWR _364_/Y sky130_fd_sc_hd__o21ai_4
XFILLER_3_55 VGND VGND VPWR VPWR sky130_fd_sc_hd__fill_1
XFILLER_8_180 VGND VGND VPWR VPWR sky130_fd_sc_hd__decap_3
Xfanout104 fanout104/A VGND VGND VPWR VPWR _400_/A sky130_fd_sc_hd__buf_6
XTAP_TAPCELL_ROW_12_119 VGND VPWR sky130_fd_sc_hd__tapvpwrvgnd_1
XFILLER_12_53 VGND VGND VPWR VPWR sky130_fd_sc_hd__decap_3
XFILLER_6_128 VGND VGND VPWR VPWR sky130_fd_sc_hd__decap_3
X_416_ _384_/A _384_/B _395_/X _397_/Y VGND VGND VPWR VPWR _416_/Y sky130_fd_sc_hd__o22ai_2
XFILLER_5_183 VGND VGND VPWR VPWR sky130_fd_sc_hd__decap_3
XFILLER_5_150 VGND VGND VPWR VPWR sky130_fd_sc_hd__decap_3
XFILLER_23_74 VGND VGND VPWR VPWR sky130_fd_sc_hd__decap_3
XFILLER_23_41 VGND VGND VPWR VPWR sky130_fd_sc_hd__decap_3
XFILLER_0_12 VGND VGND VPWR VPWR sky130_fd_sc_hd__decap_3
XFILLER_9_32 VGND VGND VPWR VPWR sky130_fd_sc_hd__decap_3
X_681_ _662_/A _662_/B input7/X VGND VGND VPWR VPWR _692_/B sky130_fd_sc_hd__o21bai_2
XFILLER_18_85 VGND VGND VPWR VPWR sky130_fd_sc_hd__decap_3
XFILLER_7_201 VGND VGND VPWR VPWR sky130_fd_sc_hd__fill_2
Xload_slew115 fanout114/X VGND VGND VPWR VPWR fanout111/A sky130_fd_sc_hd__buf_6
XFILLER_29_149 VGND VGND VPWR VPWR sky130_fd_sc_hd__decap_3
XFILLER_29_116 VGND VGND VPWR VPWR sky130_fd_sc_hd__decap_3
XFILLER_20_75 VGND VGND VPWR VPWR sky130_fd_sc_hd__decap_3
X_595_ _593_/A _593_/B input24/X VGND VGND VPWR VPWR _605_/C sky130_fd_sc_hd__o21bai_2
X_664_ _664_/A _664_/B VGND VGND VPWR VPWR _665_/B sky130_fd_sc_hd__nor2_2
XFILLER_29_73 VGND VGND VPWR VPWR sky130_fd_sc_hd__fill_2
XFILLER_6_88 VGND VGND VPWR VPWR sky130_fd_sc_hd__decap_3
XFILLER_34_141 VGND VGND VPWR VPWR sky130_fd_sc_hd__decap_3
XFILLER_19_160 VGND VGND VPWR VPWR sky130_fd_sc_hd__decap_3
Xrebuffer139 _381_/A VGND VGND VPWR VPWR _728_/A sky130_fd_sc_hd__buf_2
Xrebuffer128 _406_/A VGND VGND VPWR VPWR _627_/A sky130_fd_sc_hd__buf_2
XFILLER_17_119 VGND VGND VPWR VPWR sky130_fd_sc_hd__decap_3
X_380_ _727_/A _382_/B VGND VGND VPWR VPWR _385_/C sky130_fd_sc_hd__nand2_2
XFILLER_31_52 VGND VGND VPWR VPWR sky130_fd_sc_hd__decap_3
X_716_ _716_/A _716_/B VGND VGND VPWR VPWR _716_/Y sky130_fd_sc_hd__nand2_2
Xoutput96 _633_/Y VGND VGND VPWR VPWR S[8] sky130_fd_sc_hd__clkbuf_2
Xoutput85 _564_/Y VGND VGND VPWR VPWR S[27] sky130_fd_sc_hd__buf_6
Xoutput74 _433_/X VGND VGND VPWR VPWR S[17] sky130_fd_sc_hd__buf_4
XFILLER_16_141 VGND VGND VPWR VPWR sky130_fd_sc_hd__decap_3
X_578_ _693_/X _447_/D _578_/A3 _576_/Y VGND VGND VPWR VPWR _578_/Y sky130_fd_sc_hd__a31oi_4
X_647_ _688_/X _647_/B VGND VGND VPWR VPWR _647_/X sky130_fd_sc_hd__xor2_2
XFILLER_31_177 VGND VGND VPWR VPWR sky130_fd_sc_hd__decap_3
.ends
