* NGSPICE file created from ALU.ext - technology: sky130A

* Black-box entry subcircuit for sky130_fd_sc_hd__fill_1 abstract view
.subckt sky130_fd_sc_hd__fill_1 VGND VNB VPB VPWR
.ends

* Black-box entry subcircuit for sky130_fd_sc_hd__fill_2 abstract view
.subckt sky130_fd_sc_hd__fill_2 VGND VNB VPB VPWR
.ends

* Black-box entry subcircuit for sky130_fd_sc_hd__decap_3 abstract view
.subckt sky130_fd_sc_hd__decap_3 VGND VNB VPB VPWR
.ends

* Black-box entry subcircuit for sky130_fd_sc_hd__tapvpwrvgnd_1 abstract view
.subckt sky130_fd_sc_hd__tapvpwrvgnd_1 VGND VPWR
.ends

* Black-box entry subcircuit for sky130_fd_sc_hd__inv_2 abstract view
.subckt sky130_fd_sc_hd__inv_2 A VGND VNB VPB VPWR Y
.ends

* Black-box entry subcircuit for sky130_fd_sc_hd__nand2_2 abstract view
.subckt sky130_fd_sc_hd__nand2_2 A B VGND VNB VPB VPWR Y
.ends

* Black-box entry subcircuit for sky130_fd_sc_hd__clkdlybuf4s25_1 abstract view
.subckt sky130_fd_sc_hd__clkdlybuf4s25_1 A VGND VNB VPB VPWR X
.ends

* Black-box entry subcircuit for sky130_fd_sc_hd__nand2b_2 abstract view
.subckt sky130_fd_sc_hd__nand2b_2 A_N B VGND VNB VPB VPWR Y
.ends

* Black-box entry subcircuit for sky130_fd_sc_hd__a31o_2 abstract view
.subckt sky130_fd_sc_hd__a31o_2 A1 A2 A3 B1 VGND VNB VPB VPWR X
.ends

* Black-box entry subcircuit for sky130_fd_sc_hd__o22a_2 abstract view
.subckt sky130_fd_sc_hd__o22a_2 A1 A2 B1 B2 VGND VNB VPB VPWR X
.ends

* Black-box entry subcircuit for sky130_fd_sc_hd__and2b_2 abstract view
.subckt sky130_fd_sc_hd__and2b_2 A_N B VGND VNB VPB VPWR X
.ends

* Black-box entry subcircuit for sky130_fd_sc_hd__a21oi_2 abstract view
.subckt sky130_fd_sc_hd__a21oi_2 A1 A2 B1 VGND VNB VPB VPWR Y
.ends

* Black-box entry subcircuit for sky130_fd_sc_hd__and4_2 abstract view
.subckt sky130_fd_sc_hd__and4_2 A B C D VGND VNB VPB VPWR X
.ends

* Black-box entry subcircuit for sky130_fd_sc_hd__a21o_2 abstract view
.subckt sky130_fd_sc_hd__a21o_2 A1 A2 B1 VGND VNB VPB VPWR X
.ends

* Black-box entry subcircuit for sky130_fd_sc_hd__o21ai_2 abstract view
.subckt sky130_fd_sc_hd__o21ai_2 A1 A2 B1 VGND VNB VPB VPWR Y
.ends

* Black-box entry subcircuit for sky130_fd_sc_hd__and2_2 abstract view
.subckt sky130_fd_sc_hd__and2_2 A B VGND VNB VPB VPWR X
.ends

* Black-box entry subcircuit for sky130_fd_sc_hd__buf_2 abstract view
.subckt sky130_fd_sc_hd__buf_2 A VGND VNB VPB VPWR X
.ends

* Black-box entry subcircuit for sky130_fd_sc_hd__xnor2_2 abstract view
.subckt sky130_fd_sc_hd__xnor2_2 A B VGND VNB VPB VPWR Y
.ends

* Black-box entry subcircuit for sky130_fd_sc_hd__o311ai_2 abstract view
.subckt sky130_fd_sc_hd__o311ai_2 A1 A2 A3 B1 C1 VGND VNB VPB VPWR Y
.ends

* Black-box entry subcircuit for sky130_fd_sc_hd__o211a_2 abstract view
.subckt sky130_fd_sc_hd__o211a_2 A1 A2 B1 C1 VGND VNB VPB VPWR X
.ends

* Black-box entry subcircuit for sky130_fd_sc_hd__nor2_2 abstract view
.subckt sky130_fd_sc_hd__nor2_2 A B VGND VNB VPB VPWR Y
.ends

* Black-box entry subcircuit for sky130_fd_sc_hd__o211ai_2 abstract view
.subckt sky130_fd_sc_hd__o211ai_2 A1 A2 B1 C1 VGND VNB VPB VPWR Y
.ends

* Black-box entry subcircuit for sky130_fd_sc_hd__o221a_2 abstract view
.subckt sky130_fd_sc_hd__o221a_2 A1 A2 B1 B2 C1 VGND VNB VPB VPWR X
.ends

* Black-box entry subcircuit for sky130_fd_sc_hd__or2_2 abstract view
.subckt sky130_fd_sc_hd__or2_2 A B VGND VNB VPB VPWR X
.ends

* Black-box entry subcircuit for sky130_fd_sc_hd__o2111ai_2 abstract view
.subckt sky130_fd_sc_hd__o2111ai_2 A1 A2 B1 C1 D1 VGND VNB VPB VPWR Y
.ends

* Black-box entry subcircuit for sky130_fd_sc_hd__or3_2 abstract view
.subckt sky130_fd_sc_hd__or3_2 A B C VGND VNB VPB VPWR X
.ends

* Black-box entry subcircuit for sky130_fd_sc_hd__mux2_1 abstract view
.subckt sky130_fd_sc_hd__mux2_1 A0 A1 S VGND VNB VPB VPWR X
.ends

* Black-box entry subcircuit for sky130_fd_sc_hd__a21bo_2 abstract view
.subckt sky130_fd_sc_hd__a21bo_2 A1 A2 B1_N VGND VNB VPB VPWR X
.ends

* Black-box entry subcircuit for sky130_fd_sc_hd__a221o_2 abstract view
.subckt sky130_fd_sc_hd__a221o_2 A1 A2 B1 B2 C1 VGND VNB VPB VPWR X
.ends

* Black-box entry subcircuit for sky130_fd_sc_hd__o21a_2 abstract view
.subckt sky130_fd_sc_hd__o21a_2 A1 A2 B1 VGND VNB VPB VPWR X
.ends

* Black-box entry subcircuit for sky130_fd_sc_hd__xor2_2 abstract view
.subckt sky130_fd_sc_hd__xor2_2 A B VGND VNB VPB VPWR X
.ends

* Black-box entry subcircuit for sky130_fd_sc_hd__and3_2 abstract view
.subckt sky130_fd_sc_hd__and3_2 A B C VGND VNB VPB VPWR X
.ends

* Black-box entry subcircuit for sky130_fd_sc_hd__o31a_2 abstract view
.subckt sky130_fd_sc_hd__o31a_2 A1 A2 A3 B1 VGND VNB VPB VPWR X
.ends

* Black-box entry subcircuit for sky130_fd_sc_hd__o311a_2 abstract view
.subckt sky130_fd_sc_hd__o311a_2 A1 A2 A3 B1 C1 VGND VNB VPB VPWR X
.ends

* Black-box entry subcircuit for sky130_fd_sc_hd__or3b_2 abstract view
.subckt sky130_fd_sc_hd__or3b_2 A B C_N VGND VNB VPB VPWR X
.ends

* Black-box entry subcircuit for sky130_fd_sc_hd__a211o_2 abstract view
.subckt sky130_fd_sc_hd__a211o_2 A1 A2 B1 C1 VGND VNB VPB VPWR X
.ends

* Black-box entry subcircuit for sky130_fd_sc_hd__a211oi_2 abstract view
.subckt sky130_fd_sc_hd__a211oi_2 A1 A2 B1 C1 VGND VNB VPB VPWR Y
.ends

* Black-box entry subcircuit for sky130_fd_sc_hd__nor3b_2 abstract view
.subckt sky130_fd_sc_hd__nor3b_2 A B C_N VGND VNB VPB VPWR Y
.ends

* Black-box entry subcircuit for sky130_fd_sc_hd__or4_2 abstract view
.subckt sky130_fd_sc_hd__or4_2 A B C D VGND VNB VPB VPWR X
.ends

* Black-box entry subcircuit for sky130_fd_sc_hd__a22o_2 abstract view
.subckt sky130_fd_sc_hd__a22o_2 A1 A2 B1 B2 VGND VNB VPB VPWR X
.ends

* Black-box entry subcircuit for sky130_fd_sc_hd__o2bb2a_2 abstract view
.subckt sky130_fd_sc_hd__o2bb2a_2 A1_N A2_N B1 B2 VGND VNB VPB VPWR X
.ends

* Black-box entry subcircuit for sky130_fd_sc_hd__nand4b_2 abstract view
.subckt sky130_fd_sc_hd__nand4b_2 A_N B C D VGND VNB VPB VPWR Y
.ends

* Black-box entry subcircuit for sky130_fd_sc_hd__or4b_2 abstract view
.subckt sky130_fd_sc_hd__or4b_2 A B C D_N VGND VNB VPB VPWR X
.ends

* Black-box entry subcircuit for sky130_fd_sc_hd__o32ai_2 abstract view
.subckt sky130_fd_sc_hd__o32ai_2 A1 A2 A3 B1 B2 VGND VNB VPB VPWR Y
.ends

* Black-box entry subcircuit for sky130_fd_sc_hd__nand3_2 abstract view
.subckt sky130_fd_sc_hd__nand3_2 A B C VGND VNB VPB VPWR Y
.ends

* Black-box entry subcircuit for sky130_fd_sc_hd__o41a_2 abstract view
.subckt sky130_fd_sc_hd__o41a_2 A1 A2 A3 A4 B1 VGND VNB VPB VPWR X
.ends

* Black-box entry subcircuit for sky130_fd_sc_hd__a32o_2 abstract view
.subckt sky130_fd_sc_hd__a32o_2 A1 A2 A3 B1 B2 VGND VNB VPB VPWR X
.ends

* Black-box entry subcircuit for sky130_fd_sc_hd__a2bb2o_2 abstract view
.subckt sky130_fd_sc_hd__a2bb2o_2 A1_N A2_N B1 B2 VGND VNB VPB VPWR X
.ends

* Black-box entry subcircuit for sky130_fd_sc_hd__o21ba_2 abstract view
.subckt sky130_fd_sc_hd__o21ba_2 A1 A2 B1_N VGND VNB VPB VPWR X
.ends

* Black-box entry subcircuit for sky130_fd_sc_hd__clkbuf_2 abstract view
.subckt sky130_fd_sc_hd__clkbuf_2 A VGND VNB VPB VPWR X
.ends

* Black-box entry subcircuit for sky130_fd_sc_hd__a311o_2 abstract view
.subckt sky130_fd_sc_hd__a311o_2 A1 A2 A3 B1 C1 VGND VNB VPB VPWR X
.ends

* Black-box entry subcircuit for sky130_fd_sc_hd__a311oi_2 abstract view
.subckt sky130_fd_sc_hd__a311oi_2 A1 A2 A3 B1 C1 VGND VNB VPB VPWR Y
.ends

* Black-box entry subcircuit for sky130_fd_sc_hd__nand4_2 abstract view
.subckt sky130_fd_sc_hd__nand4_2 A B C D VGND VNB VPB VPWR Y
.ends

* Black-box entry subcircuit for sky130_fd_sc_hd__nand3b_2 abstract view
.subckt sky130_fd_sc_hd__nand3b_2 A_N B C VGND VNB VPB VPWR Y
.ends

* Black-box entry subcircuit for sky130_fd_sc_hd__and3b_2 abstract view
.subckt sky130_fd_sc_hd__and3b_2 A_N B C VGND VNB VPB VPWR X
.ends

.subckt ALU A[0] A[10] A[11] A[12] A[13] A[14] A[15] A[16] A[17] A[18] A[19] A[1]
+ A[20] A[21] A[22] A[23] A[24] A[25] A[26] A[27] A[28] A[29] A[2] A[30] A[31] A[3]
+ A[4] A[5] A[6] A[7] A[8] A[9] B[0] B[10] B[11] B[12] B[13] B[14] B[15] B[16] B[17]
+ B[18] B[19] B[1] B[20] B[21] B[22] B[23] B[24] B[25] B[26] B[27] B[28] B[29] B[2]
+ B[30] B[31] B[3] B[4] B[5] B[6] B[7] B[8] B[9] VGND VPWR opCode[0] opCode[1] opCode[2]
+ statusIn[0] statusIn[1] statusIn[2] statusOut y[0] y[10] y[11] y[12] y[13] y[14]
+ y[15] y[16] y[17] y[18] y[19] y[1] y[20] y[21] y[22] y[23] y[24] y[25] y[26] y[27]
+ y[28] y[29] y[2] y[30] y[31] y[3] y[4] y[5] y[6] y[7] y[8] y[9]
XFILLER_22_144 VGND VGND VPWR VPWR sky130_fd_sc_hd__fill_1
XFILLER_13_166 VGND VGND VPWR VPWR sky130_fd_sc_hd__fill_2
XFILLER_26_85 VGND VGND VPWR VPWR sky130_fd_sc_hd__fill_1
XFILLER_9_104 VGND VGND VPWR VPWR sky130_fd_sc_hd__decap_3
XTAP_TAPCELL_ROW_15_106 VGND VPWR sky130_fd_sc_hd__tapvpwrvgnd_1
X_432_ _520_/B VGND VGND VPWR VPWR _432_/Y sky130_fd_sc_hd__inv_2
X_501_ _694_/A _501_/B VGND VGND VPWR VPWR _501_/Y sky130_fd_sc_hd__nand2_2
Xfanout127 _881_/A VGND VGND VPWR VPWR _842_/S sky130_fd_sc_hd__clkdlybuf4s25_1
Xfanout116 _447_/X VGND VGND VPWR VPWR _824_/A sky130_fd_sc_hd__clkdlybuf4s25_1
XFILLER_10_103 VGND VGND VPWR VPWR sky130_fd_sc_hd__decap_3
XTAP_TAPCELL_ROW_20_120 VGND VPWR sky130_fd_sc_hd__tapvpwrvgnd_1
XFILLER_0_57 VGND VGND VPWR VPWR sky130_fd_sc_hd__fill_2
XFILLER_9_11 VGND VGND VPWR VPWR sky130_fd_sc_hd__fill_1
XFILLER_9_88 VGND VGND VPWR VPWR sky130_fd_sc_hd__decap_3
XPHY_EDGE_ROW_8_Left_36 VGND VGND VPWR VPWR sky130_fd_sc_hd__decap_3
XFILLER_15_6 VGND VGND VPWR VPWR sky130_fd_sc_hd__fill_1
X_878_ _877_/B _878_/B VGND VGND VPWR VPWR _878_/Y sky130_fd_sc_hd__nand2b_2
X_680_ _692_/B _672_/B _751_/A1 _679_/X VGND VGND VPWR VPWR _680_/X sky130_fd_sc_hd__a31o_2
X_594_ _844_/A _583_/Y _607_/B _710_/A VGND VGND VPWR VPWR _594_/X sky130_fd_sc_hd__o22a_2
X_801_ _787_/B _801_/B VGND VGND VPWR VPWR _801_/X sky130_fd_sc_hd__and2b_2
X_732_ _759_/A _721_/X _731_/X VGND VGND VPWR VPWR _732_/Y sky130_fd_sc_hd__a21oi_2
X_663_ _663_/A _663_/B _663_/C _663_/D VGND VGND VPWR VPWR _663_/X sky130_fd_sc_hd__and4_2
XFILLER_13_3 VGND VGND VPWR VPWR sky130_fd_sc_hd__fill_1
XFILLER_17_109 VGND VGND VPWR VPWR sky130_fd_sc_hd__decap_3
XFILLER_25_142 VGND VGND VPWR VPWR sky130_fd_sc_hd__decap_3
XTAP_TAPCELL_ROW_18_115 VGND VPWR sky130_fd_sc_hd__tapvpwrvgnd_1
X_577_ _599_/B _564_/X _576_/X VGND VGND VPWR VPWR _577_/X sky130_fd_sc_hd__a21o_2
Xoutput75 _636_/Y VGND VGND VPWR VPWR y[14] sky130_fd_sc_hd__clkdlybuf4s25_1
Xoutput86 _784_/Y VGND VGND VPWR VPWR y[24] sky130_fd_sc_hd__clkdlybuf4s25_1
Xoutput97 _517_/Y VGND VGND VPWR VPWR y[5] sky130_fd_sc_hd__clkdlybuf4s25_1
X_715_ _700_/X _706_/X _702_/B VGND VGND VPWR VPWR _715_/Y sky130_fd_sc_hd__o21ai_2
X_646_ _646_/A VGND VGND VPWR VPWR _646_/Y sky130_fd_sc_hd__inv_2
XFILLER_22_123 VGND VGND VPWR VPWR sky130_fd_sc_hd__decap_3
XFILLER_13_101 VGND VGND VPWR VPWR sky130_fd_sc_hd__decap_3
XFILLER_26_75 VGND VGND VPWR VPWR sky130_fd_sc_hd__fill_2
XPHY_EDGE_ROW_21_Left_49 VGND VGND VPWR VPWR sky130_fd_sc_hd__decap_3
X_431_ _520_/A VGND VGND VPWR VPWR _431_/Y sky130_fd_sc_hd__inv_2
X_500_ _500_/A _500_/B VGND VGND VPWR VPWR _501_/B sky130_fd_sc_hd__and2_2
X_629_ _629_/A _629_/B VGND VGND VPWR VPWR _629_/Y sky130_fd_sc_hd__nand2_2
Xfanout117 _447_/X VGND VGND VPWR VPWR _885_/B2 sky130_fd_sc_hd__clkdlybuf4s25_1
XTAP_TAPCELL_ROW_20_121 VGND VPWR sky130_fd_sc_hd__tapvpwrvgnd_1
XFILLER_23_32 VGND VGND VPWR VPWR sky130_fd_sc_hd__decap_3
XFILLER_23_54 VGND VGND VPWR VPWR sky130_fd_sc_hd__fill_2
XPHY_EDGE_ROW_12_Right_12 VGND VGND VPWR VPWR sky130_fd_sc_hd__decap_3
XPHY_EDGE_ROW_21_Right_21 VGND VGND VPWR VPWR sky130_fd_sc_hd__decap_3
XPHY_EDGE_ROW_24_Left_52 VGND VGND VPWR VPWR sky130_fd_sc_hd__decap_3
XFILLER_18_32 VGND VGND VPWR VPWR sky130_fd_sc_hd__fill_1
XFILLER_18_43 VGND VGND VPWR VPWR sky130_fd_sc_hd__fill_1
XFILLER_18_98 VGND VGND VPWR VPWR sky130_fd_sc_hd__decap_3
Xload_slew128 _842_/S VGND VGND VPWR VPWR _762_/A1 sky130_fd_sc_hd__buf_2
X_877_ _878_/B _877_/B VGND VGND VPWR VPWR _877_/X sky130_fd_sc_hd__and2b_2
XFILLER_20_55 VGND VGND VPWR VPWR sky130_fd_sc_hd__decap_3
XFILLER_20_77 VGND VGND VPWR VPWR sky130_fd_sc_hd__decap_3
XFILLER_20_88 VGND VGND VPWR VPWR sky130_fd_sc_hd__fill_1
X_800_ _798_/Y _800_/B VGND VGND VPWR VPWR _819_/C sky130_fd_sc_hd__nand2b_2
X_731_ _714_/B _731_/B VGND VGND VPWR VPWR _731_/X sky130_fd_sc_hd__and2b_2
X_662_ _662_/A _662_/B VGND VGND VPWR VPWR _662_/Y sky130_fd_sc_hd__nand2_2
X_593_ _607_/B _593_/B VGND VGND VPWR VPWR _593_/Y sky130_fd_sc_hd__xnor2_2
XFILLER_25_132 VGND VGND VPWR VPWR sky130_fd_sc_hd__fill_2
XPHY_EDGE_ROW_6_Right_6 VGND VGND VPWR VPWR sky130_fd_sc_hd__decap_3
XFILLER_16_165 VGND VGND VPWR VPWR sky130_fd_sc_hd__fill_1
X_576_ _560_/A _576_/B VGND VGND VPWR VPWR _576_/X sky130_fd_sc_hd__and2b_2
Xoutput76 _652_/X VGND VGND VPWR VPWR y[15] sky130_fd_sc_hd__clkdlybuf4s25_1
Xoutput87 _797_/Y VGND VGND VPWR VPWR y[25] sky130_fd_sc_hd__clkdlybuf4s25_1
Xoutput98 _530_/Y VGND VGND VPWR VPWR y[6] sky130_fd_sc_hd__clkdlybuf4s25_1
X_714_ _731_/B _714_/B VGND VGND VPWR VPWR _759_/A sky130_fd_sc_hd__xnor2_2
X_645_ _597_/Y _629_/B _663_/C _644_/Y _624_/Y VGND VGND VPWR VPWR _646_/A sky130_fd_sc_hd__o311ai_2
XFILLER_22_168 VGND VGND VPWR VPWR sky130_fd_sc_hd__fill_1
XTAP_TAPCELL_ROW_23_130 VGND VPWR sky130_fd_sc_hd__tapvpwrvgnd_1
X_430_ _491_/A VGND VGND VPWR VPWR _430_/Y sky130_fd_sc_hd__inv_2
XFILLER_8_161 VGND VGND VPWR VPWR sky130_fd_sc_hd__fill_1
X_559_ _560_/A _576_/B VGND VGND VPWR VPWR _559_/Y sky130_fd_sc_hd__nand2_2
X_628_ _616_/Y _663_/B VGND VGND VPWR VPWR _628_/Y sky130_fd_sc_hd__nand2b_2
Xfanout129 _888_/A VGND VGND VPWR VPWR _449_/A sky130_fd_sc_hd__clkdlybuf4s25_1
Xfanout118 _447_/X VGND VGND VPWR VPWR _871_/A1 sky130_fd_sc_hd__clkdlybuf4s25_1
XFILLER_9_68 VGND VGND VPWR VPWR sky130_fd_sc_hd__decap_3
XFILLER_18_88 VGND VGND VPWR VPWR sky130_fd_sc_hd__fill_2
X_876_ _883_/A VGND VGND VPWR VPWR _876_/Y sky130_fd_sc_hd__inv_2
XFILLER_6_69 VGND VGND VPWR VPWR sky130_fd_sc_hd__decap_3
X_592_ _717_/A _591_/Y _590_/X VGND VGND VPWR VPWR _593_/B sky130_fd_sc_hd__a21o_2
X_730_ _759_/A _760_/A _821_/C1 _713_/Y VGND VGND VPWR VPWR _730_/X sky130_fd_sc_hd__o211a_2
X_661_ _606_/X _658_/D _658_/X _500_/B VGND VGND VPWR VPWR _662_/B sky130_fd_sc_hd__o22a_2
X_859_ _877_/B _878_/B VGND VGND VPWR VPWR _859_/Y sky130_fd_sc_hd__nor2_2
X_575_ _599_/B _575_/B VGND VGND VPWR VPWR _575_/X sky130_fd_sc_hd__and2_2
Xoutput77 _670_/X VGND VGND VPWR VPWR y[16] sky130_fd_sc_hd__clkdlybuf4s25_1
Xoutput88 _810_/Y VGND VGND VPWR VPWR y[26] sky130_fd_sc_hd__clkdlybuf4s25_1
Xoutput99 _539_/Y VGND VGND VPWR VPWR y[7] sky130_fd_sc_hd__clkdlybuf4s25_1
X_713_ _731_/B _714_/B VGND VGND VPWR VPWR _713_/Y sky130_fd_sc_hd__nand2_2
X_644_ _625_/A _642_/B _615_/A _615_/B VGND VGND VPWR VPWR _644_/Y sky130_fd_sc_hd__o211ai_2
XFILLER_22_114 VGND VGND VPWR VPWR sky130_fd_sc_hd__decap_3
XFILLER_26_11 VGND VGND VPWR VPWR sky130_fd_sc_hd__decap_3
XFILLER_26_22 VGND VGND VPWR VPWR sky130_fd_sc_hd__fill_1
XFILLER_7_90 VGND VGND VPWR VPWR sky130_fd_sc_hd__decap_3
XFILLER_9_107 VGND VGND VPWR VPWR sky130_fd_sc_hd__decap_3
X_489_ _886_/A1 _486_/X _488_/X VGND VGND VPWR VPWR _489_/Y sky130_fd_sc_hd__o21ai_2
X_558_ _766_/A1 _555_/Y _557_/X VGND VGND VPWR VPWR _558_/Y sky130_fd_sc_hd__o21ai_2
X_627_ _597_/Y _629_/B _614_/Y _821_/C1 VGND VGND VPWR VPWR _627_/X sky130_fd_sc_hd__o211a_2
XFILLER_10_106 VGND VGND VPWR VPWR sky130_fd_sc_hd__decap_3
Xfanout119 _808_/A VGND VGND VPWR VPWR _795_/A sky130_fd_sc_hd__clkdlybuf4s25_1
Xfanout108 _451_/Y VGND VGND VPWR VPWR _844_/A sky130_fd_sc_hd__clkdlybuf4s25_1
XFILLER_2_157 VGND VGND VPWR VPWR sky130_fd_sc_hd__fill_2
XFILLER_18_67 VGND VGND VPWR VPWR sky130_fd_sc_hd__decap_3
X_875_ _875_/A _884_/B VGND VGND VPWR VPWR _883_/A sky130_fd_sc_hd__nand2_2
XTAP_TAPCELL_ROW_10_90 VGND VPWR sky130_fd_sc_hd__tapvpwrvgnd_1
X_591_ _607_/A _575_/X _589_/X VGND VGND VPWR VPWR _591_/Y sky130_fd_sc_hd__a21oi_2
X_660_ _545_/X _657_/X _658_/X _500_/A _659_/Y VGND VGND VPWR VPWR _662_/A sky130_fd_sc_hd__o221a_2
X_858_ _877_/B _878_/B VGND VGND VPWR VPWR _861_/A sky130_fd_sc_hd__nand2_2
X_789_ _819_/A _789_/B VGND VGND VPWR VPWR _790_/C sky130_fd_sc_hd__or2_2
XFILLER_15_57 VGND VGND VPWR VPWR sky130_fd_sc_hd__fill_1
XFILLER_25_145 VGND VGND VPWR VPWR sky130_fd_sc_hd__fill_1
XFILLER_25_167 VGND VGND VPWR VPWR sky130_fd_sc_hd__fill_1
Xoutput78 _681_/X VGND VGND VPWR VPWR y[17] sky130_fd_sc_hd__clkdlybuf4s25_1
Xoutput89 _826_/X VGND VGND VPWR VPWR y[27] sky130_fd_sc_hd__clkdlybuf4s25_1
X_712_ _795_/A _709_/Y _711_/X VGND VGND VPWR VPWR _712_/X sky130_fd_sc_hd__a21o_2
XFILLER_11_3 VGND VGND VPWR VPWR sky130_fd_sc_hd__fill_1
X_574_ _540_/Y _599_/B _573_/Y _559_/Y _609_/S VGND VGND VPWR VPWR _574_/Y sky130_fd_sc_hd__o2111ai_2
X_643_ _625_/Y _631_/X _642_/X VGND VGND VPWR VPWR _664_/B sky130_fd_sc_hd__a21oi_2
XFILLER_22_126 VGND VGND VPWR VPWR sky130_fd_sc_hd__fill_1
X_488_ _668_/A _479_/B _497_/D _885_/B2 _487_/X VGND VGND VPWR VPWR _488_/X sky130_fd_sc_hd__o221a_2
X_557_ _736_/A1 _540_/Y _599_/A _710_/A _556_/Y VGND VGND VPWR VPWR _557_/X sky130_fd_sc_hd__o221a_2
X_626_ _663_/A _626_/B _663_/B VGND VGND VPWR VPWR _626_/X sky130_fd_sc_hd__or3_2
XFILLER_12_181 VGND VGND VPWR VPWR sky130_fd_sc_hd__fill_1
XFILLER_8_141 VGND VGND VPWR VPWR sky130_fd_sc_hd__decap_3
XTAP_TAPCELL_ROW_3_70 VGND VPWR sky130_fd_sc_hd__tapvpwrvgnd_1
Xfanout109 _782_/A VGND VGND VPWR VPWR _724_/B1 sky130_fd_sc_hd__clkdlybuf4s25_1
X_609_ _605_/Y _626_/B _609_/S VGND VGND VPWR VPWR _610_/B sky130_fd_sc_hd__mux2_1
XFILLER_23_35 VGND VGND VPWR VPWR sky130_fd_sc_hd__fill_1
XFILLER_2_125 VGND VGND VPWR VPWR sky130_fd_sc_hd__fill_2
XTAP_TAPCELL_ROW_0_60 VGND VPWR sky130_fd_sc_hd__tapvpwrvgnd_1
X_874_ _874_/A _874_/B VGND VGND VPWR VPWR _884_/B sky130_fd_sc_hd__or2_2
XTAP_TAPCELL_ROW_10_91 VGND VPWR sky130_fd_sc_hd__tapvpwrvgnd_1
X_590_ _607_/A _573_/Y _587_/X _609_/S VGND VGND VPWR VPWR _590_/X sky130_fd_sc_hd__o211a_2
XFILLER_10_80 VGND VGND VPWR VPWR sky130_fd_sc_hd__decap_3
XFILLER_10_91 VGND VGND VPWR VPWR sky130_fd_sc_hd__decap_3
XFILLER_6_27 VGND VGND VPWR VPWR sky130_fd_sc_hd__fill_1
X_857_ _853_/Y _854_/X _856_/X VGND VGND VPWR VPWR _857_/X sky130_fd_sc_hd__a21bo_2
X_788_ _788_/A _788_/B VGND VGND VPWR VPWR _819_/B sky130_fd_sc_hd__nand2_2
XFILLER_25_113 VGND VGND VPWR VPWR sky130_fd_sc_hd__fill_1
XPHY_EDGE_ROW_19_Right_19 VGND VGND VPWR VPWR sky130_fd_sc_hd__decap_3
X_573_ _658_/B _573_/B VGND VGND VPWR VPWR _573_/Y sky130_fd_sc_hd__nand2b_2
Xoutput79 _699_/Y VGND VGND VPWR VPWR y[18] sky130_fd_sc_hd__clkdlybuf4s25_1
X_711_ _751_/A1 _700_/X _702_/B _724_/B1 _710_/Y VGND VGND VPWR VPWR _711_/X sky130_fd_sc_hd__a221o_2
X_642_ _625_/A _642_/B VGND VGND VPWR VPWR _642_/X sky130_fd_sc_hd__and2b_2
XPHY_EDGE_ROW_15_Left_43 VGND VGND VPWR VPWR sky130_fd_sc_hd__decap_3
XFILLER_26_57 VGND VGND VPWR VPWR sky130_fd_sc_hd__decap_3
X_625_ _625_/A _642_/B VGND VGND VPWR VPWR _625_/Y sky130_fd_sc_hd__xnor2_2
X_487_ _844_/A _487_/B VGND VGND VPWR VPWR _487_/X sky130_fd_sc_hd__or2_2
X_556_ _541_/A _564_/B _724_/B1 VGND VGND VPWR VPWR _556_/Y sky130_fd_sc_hd__o21ai_2
XPHY_EDGE_ROW_0_Left_28 VGND VGND VPWR VPWR sky130_fd_sc_hd__decap_3
X_539_ _766_/A1 _536_/Y _538_/X VGND VGND VPWR VPWR _539_/Y sky130_fd_sc_hd__o21ai_2
X_608_ _573_/Y _658_/C _606_/X VGND VGND VPWR VPWR _626_/B sky130_fd_sc_hd__o21a_2
X_890_ _881_/A _887_/Y _889_/Y VGND VGND VPWR VPWR _890_/X sky130_fd_sc_hd__a21o_2
XTAP_TAPCELL_ROW_0_61 VGND VPWR sky130_fd_sc_hd__tapvpwrvgnd_1
XPHY_EDGE_ROW_3_Left_31 VGND VGND VPWR VPWR sky130_fd_sc_hd__decap_3
X_873_ _874_/A _874_/B VGND VGND VPWR VPWR _875_/A sky130_fd_sc_hd__nand2_2
X_856_ _451_/Y _850_/A _850_/X _871_/A1 _855_/Y VGND VGND VPWR VPWR _856_/X sky130_fd_sc_hd__o221a_2
X_787_ _801_/B _787_/B VGND VGND VPWR VPWR _788_/B sky130_fd_sc_hd__or2_2
XFILLER_25_169 VGND VGND VPWR VPWR sky130_fd_sc_hd__fill_1
XFILLER_16_114 VGND VGND VPWR VPWR sky130_fd_sc_hd__decap_3
X_572_ _599_/A _599_/B VGND VGND VPWR VPWR _658_/B sky130_fd_sc_hd__or2_2
Xoutput69 _890_/X VGND VGND VPWR VPWR statusOut sky130_fd_sc_hd__clkdlybuf4s25_1
X_710_ _710_/A _834_/C VGND VGND VPWR VPWR _710_/Y sky130_fd_sc_hd__nor2_2
X_641_ _628_/Y _663_/C VGND VGND VPWR VPWR _641_/Y sky130_fd_sc_hd__nand2b_2
XFILLER_22_117 VGND VGND VPWR VPWR sky130_fd_sc_hd__decap_3
XFILLER_7_93 VGND VGND VPWR VPWR sky130_fd_sc_hd__fill_2
X_839_ _772_/X _838_/C _817_/X VGND VGND VPWR VPWR _839_/X sky130_fd_sc_hd__a21o_2
XFILLER_12_161 VGND VGND VPWR VPWR sky130_fd_sc_hd__fill_1
XFILLER_16_80 VGND VGND VPWR VPWR sky130_fd_sc_hd__decap_3
XTAP_TAPCELL_ROW_14_101 VGND VPWR sky130_fd_sc_hd__tapvpwrvgnd_1
X_486_ _497_/D _486_/B VGND VGND VPWR VPWR _486_/X sky130_fd_sc_hd__xor2_2
X_555_ _563_/A _555_/B VGND VGND VPWR VPWR _555_/Y sky130_fd_sc_hd__xnor2_2
X_624_ _625_/A _642_/B VGND VGND VPWR VPWR _624_/Y sky130_fd_sc_hd__nand2_2
XFILLER_10_109 VGND VGND VPWR VPWR sky130_fd_sc_hd__decap_3
XFILLER_12_27 VGND VGND VPWR VPWR sky130_fd_sc_hd__fill_1
X_538_ _736_/A1 _531_/Y _551_/B _710_/A _537_/Y VGND VGND VPWR VPWR _538_/X sky130_fd_sc_hd__o221a_2
X_607_ _607_/A _607_/B VGND VGND VPWR VPWR _658_/C sky130_fd_sc_hd__or2_2
XFILLER_23_48 VGND VGND VPWR VPWR sky130_fd_sc_hd__decap_3
XFILLER_4_83 VGND VGND VPWR VPWR sky130_fd_sc_hd__fill_1
X_469_ _456_/A _469_/B VGND VGND VPWR VPWR _469_/X sky130_fd_sc_hd__and2b_2
XFILLER_18_26 VGND VGND VPWR VPWR sky130_fd_sc_hd__fill_2
XFILLER_27_3 VGND VGND VPWR VPWR sky130_fd_sc_hd__decap_3
X_872_ _868_/Y _869_/X _871_/Y VGND VGND VPWR VPWR _872_/X sky130_fd_sc_hd__a21o_2
XFILLER_20_16 VGND VGND VPWR VPWR sky130_fd_sc_hd__decap_3
XFILLER_20_49 VGND VGND VPWR VPWR sky130_fd_sc_hd__decap_3
XFILLER_10_60 VGND VGND VPWR VPWR sky130_fd_sc_hd__decap_3
XFILLER_6_29 VGND VGND VPWR VPWR sky130_fd_sc_hd__decap_3
X_855_ _855_/A _855_/B VGND VGND VPWR VPWR _855_/Y sky130_fd_sc_hd__nand2_2
X_786_ _801_/B _787_/B VGND VGND VPWR VPWR _786_/Y sky130_fd_sc_hd__nor2_2
XFILLER_16_137 VGND VGND VPWR VPWR sky130_fd_sc_hd__decap_3
XPHY_EDGE_ROW_1_Right_1 VGND VGND VPWR VPWR sky130_fd_sc_hd__decap_3
X_571_ _571_/A _588_/B VGND VGND VPWR VPWR _571_/Y sky130_fd_sc_hd__xnor2_2
X_640_ _663_/D VGND VGND VPWR VPWR _664_/A sky130_fd_sc_hd__inv_2
XFILLER_21_81 VGND VGND VPWR VPWR sky130_fd_sc_hd__fill_2
XFILLER_7_72 VGND VGND VPWR VPWR sky130_fd_sc_hd__fill_2
XTAP_TAPCELL_ROW_17_110 VGND VPWR sky130_fd_sc_hd__tapvpwrvgnd_1
X_838_ _838_/A _838_/B _838_/C VGND VGND VPWR VPWR _838_/X sky130_fd_sc_hd__and3_2
X_769_ _782_/B _790_/B VGND VGND VPWR VPWR _819_/A sky130_fd_sc_hd__nand2_2
XFILLER_21_162 VGND VGND VPWR VPWR sky130_fd_sc_hd__fill_1
XFILLER_8_144 VGND VGND VPWR VPWR sky130_fd_sc_hd__fill_1
XFILLER_8_188 VGND VGND VPWR VPWR sky130_fd_sc_hd__fill_2
XTAP_TAPCELL_ROW_14_102 VGND VPWR sky130_fd_sc_hd__tapvpwrvgnd_1
X_485_ _694_/A _482_/X _495_/B _484_/Y VGND VGND VPWR VPWR _486_/B sky130_fd_sc_hd__o31a_2
X_554_ _609_/S _563_/B _548_/Y VGND VGND VPWR VPWR _555_/B sky130_fd_sc_hd__o21ai_2
X_623_ _766_/A1 _620_/Y _622_/X VGND VGND VPWR VPWR _623_/Y sky130_fd_sc_hd__o21ai_2
XFILLER_4_73 VGND VGND VPWR VPWR sky130_fd_sc_hd__decap_3
X_468_ _468_/A _497_/B VGND VGND VPWR VPWR _468_/X sky130_fd_sc_hd__or2_2
X_537_ _532_/A _549_/B _724_/B1 VGND VGND VPWR VPWR _537_/Y sky130_fd_sc_hd__o21ai_2
X_606_ _583_/Y _587_/X _584_/Y VGND VGND VPWR VPWR _606_/X sky130_fd_sc_hd__o21a_2
XFILLER_23_16 VGND VGND VPWR VPWR sky130_fd_sc_hd__fill_2
X_871_ _871_/A1 _868_/A _870_/X VGND VGND VPWR VPWR _871_/Y sky130_fd_sc_hd__o21ai_2
XFILLER_10_72 VGND VGND VPWR VPWR sky130_fd_sc_hd__fill_2
XFILLER_10_83 VGND VGND VPWR VPWR sky130_fd_sc_hd__fill_1
XFILLER_10_94 VGND VGND VPWR VPWR sky130_fd_sc_hd__decap_3
XFILLER_19_113 VGND VGND VPWR VPWR sky130_fd_sc_hd__fill_1
X_854_ _850_/X _851_/X _852_/X _808_/A VGND VGND VPWR VPWR _854_/X sky130_fd_sc_hd__o31a_2
XFILLER_19_70 VGND VGND VPWR VPWR sky130_fd_sc_hd__fill_1
X_785_ _801_/B _787_/B VGND VGND VPWR VPWR _788_/A sky130_fd_sc_hd__nand2_2
X_570_ _571_/A _588_/B VGND VGND VPWR VPWR _570_/Y sky130_fd_sc_hd__nand2_2
XFILLER_21_93 VGND VGND VPWR VPWR sky130_fd_sc_hd__decap_3
XTAP_TAPCELL_ROW_17_111 VGND VPWR sky130_fd_sc_hd__tapvpwrvgnd_1
X_837_ _813_/B _837_/B VGND VGND VPWR VPWR _837_/X sky130_fd_sc_hd__and2b_2
X_768_ _791_/B _768_/B VGND VGND VPWR VPWR _790_/B sky130_fd_sc_hd__nand2_2
X_699_ _886_/A1 _696_/X _698_/X VGND VGND VPWR VPWR _699_/Y sky130_fd_sc_hd__o21ai_2
XFILLER_21_141 VGND VGND VPWR VPWR sky130_fd_sc_hd__decap_3
XPHY_EDGE_ROW_15_Right_15 VGND VGND VPWR VPWR sky130_fd_sc_hd__decap_3
XPHY_EDGE_ROW_24_Right_24 VGND VGND VPWR VPWR sky130_fd_sc_hd__decap_3
XFILLER_16_71 VGND VGND VPWR VPWR sky130_fd_sc_hd__fill_1
XTAP_TAPCELL_ROW_14_103 VGND VPWR sky130_fd_sc_hd__tapvpwrvgnd_1
X_484_ _465_/Y _467_/X _480_/X _694_/A VGND VGND VPWR VPWR _484_/Y sky130_fd_sc_hd__o211ai_2
X_553_ _524_/B _600_/D _550_/X VGND VGND VPWR VPWR _563_/B sky130_fd_sc_hd__a21oi_2
X_622_ _736_/A1 _614_/Y _629_/B _710_/A _621_/Y VGND VGND VPWR VPWR _622_/X sky130_fd_sc_hd__o221a_2
XPHY_EDGE_ROW_19_Left_47 VGND VGND VPWR VPWR sky130_fd_sc_hd__decap_3
X_467_ _497_/A _497_/B _498_/A VGND VGND VPWR VPWR _467_/X sky130_fd_sc_hd__o21a_2
X_536_ _551_/B _536_/B VGND VGND VPWR VPWR _536_/Y sky130_fd_sc_hd__xnor2_2
X_605_ _616_/B VGND VGND VPWR VPWR _605_/Y sky130_fd_sc_hd__inv_2
X_519_ _520_/A _520_/B VGND VGND VPWR VPWR _519_/Y sky130_fd_sc_hd__nor2_2
X_870_ _870_/A1 _861_/A _859_/Y _451_/Y VGND VGND VPWR VPWR _870_/X sky130_fd_sc_hd__o22a_2
XPHY_EDGE_ROW_7_Left_35 VGND VGND VPWR VPWR sky130_fd_sc_hd__decap_3
XFILLER_19_93 VGND VGND VPWR VPWR sky130_fd_sc_hd__decap_3
X_853_ _851_/X _852_/X _850_/X VGND VGND VPWR VPWR _853_/Y sky130_fd_sc_hd__o21ai_2
X_784_ _886_/A1 _781_/X _783_/X VGND VGND VPWR VPWR _784_/Y sky130_fd_sc_hd__o21ai_2
XFILLER_18_180 VGND VGND VPWR VPWR sky130_fd_sc_hd__fill_2
XFILLER_16_106 VGND VGND VPWR VPWR sky130_fd_sc_hd__fill_1
X_836_ _836_/A _836_/B VGND VGND VPWR VPWR _836_/X sky130_fd_sc_hd__and2_2
X_767_ _791_/B _768_/B VGND VGND VPWR VPWR _782_/B sky130_fd_sc_hd__or2_2
XTAP_TAPCELL_ROW_17_112 VGND VPWR sky130_fd_sc_hd__tapvpwrvgnd_1
X_698_ _844_/A _685_/B _834_/A _885_/B2 _697_/Y VGND VGND VPWR VPWR _698_/X sky130_fd_sc_hd__o221a_2
XFILLER_12_131 VGND VGND VPWR VPWR sky130_fd_sc_hd__fill_2
XFILLER_16_83 VGND VGND VPWR VPWR sky130_fd_sc_hd__fill_1
X_483_ _483_/A _483_/B _497_/B _498_/B VGND VGND VPWR VPWR _495_/B sky130_fd_sc_hd__and4_2
X_552_ _522_/X _600_/D _550_/X VGND VGND VPWR VPWR _552_/Y sky130_fd_sc_hd__a21oi_2
X_621_ _615_/A _615_/B _724_/B1 VGND VGND VPWR VPWR _621_/Y sky130_fd_sc_hd__o21ai_2
X_819_ _819_/A _819_/B _819_/C VGND VGND VPWR VPWR _832_/B sky130_fd_sc_hd__or3_2
XPHY_EDGE_ROW_20_Left_48 VGND VGND VPWR VPWR sky130_fd_sc_hd__decap_3
X_466_ _466_/A _481_/B VGND VGND VPWR VPWR _498_/B sky130_fd_sc_hd__xnor2_2
X_535_ _520_/A _432_/Y _609_/S _533_/X _534_/Y VGND VGND VPWR VPWR _536_/B sky130_fd_sc_hd__o311a_2
X_604_ _493_/Y _600_/Y _603_/X VGND VGND VPWR VPWR _616_/B sky130_fd_sc_hd__o21ai_2
XFILLER_1_130 VGND VGND VPWR VPWR sky130_fd_sc_hd__fill_1
XFILLER_1_174 VGND VGND VPWR VPWR sky130_fd_sc_hd__fill_1
XFILLER_18_29 VGND VGND VPWR VPWR sky130_fd_sc_hd__decap_3
X_449_ _449_/A _888_/B _451_/C VGND VGND VPWR VPWR _449_/X sky130_fd_sc_hd__or3b_2
X_518_ _520_/A _520_/B VGND VGND VPWR VPWR _518_/Y sky130_fd_sc_hd__nand2_2
XFILLER_1_32 VGND VGND VPWR VPWR sky130_fd_sc_hd__decap_3
XFILLER_27_6 VGND VGND VPWR VPWR sky130_fd_sc_hd__decap_3
XPHY_EDGE_ROW_23_Left_51 VGND VGND VPWR VPWR sky130_fd_sc_hd__decap_3
XFILLER_20_19 VGND VGND VPWR VPWR sky130_fd_sc_hd__fill_1
XFILLER_10_63 VGND VGND VPWR VPWR sky130_fd_sc_hd__decap_3
XFILLER_10_85 VGND VGND VPWR VPWR sky130_fd_sc_hd__decap_3
XFILLER_19_137 VGND VGND VPWR VPWR sky130_fd_sc_hd__fill_1
X_852_ _829_/A _435_/Y _830_/Y _841_/Y _881_/A VGND VGND VPWR VPWR _852_/X sky130_fd_sc_hd__o221a_2
X_783_ _668_/A _790_/B _819_/A _885_/B2 _782_/Y VGND VGND VPWR VPWR _783_/X sky130_fd_sc_hd__o221a_2
XFILLER_25_129 VGND VGND VPWR VPWR sky130_fd_sc_hd__decap_3
X_835_ _662_/A _662_/B _832_/X _834_/X VGND VGND VPWR VPWR _836_/B sky130_fd_sc_hd__a211o_2
X_766_ _766_/A1 _763_/X _765_/X VGND VGND VPWR VPWR _766_/Y sky130_fd_sc_hd__o21ai_2
X_697_ _855_/A _697_/B VGND VGND VPWR VPWR _697_/Y sky130_fd_sc_hd__nand2_2
XFILLER_26_29 VGND VGND VPWR VPWR sky130_fd_sc_hd__fill_2
XPHY_EDGE_ROW_5_Right_5 VGND VGND VPWR VPWR sky130_fd_sc_hd__decap_3
X_551_ _551_/A _551_/B VGND VGND VPWR VPWR _600_/D sky130_fd_sc_hd__and2_2
X_620_ _663_/B _620_/B VGND VGND VPWR VPWR _620_/Y sky130_fd_sc_hd__xnor2_2
XFILLER_8_114 VGND VGND VPWR VPWR sky130_fd_sc_hd__fill_1
X_482_ _498_/B _470_/X _481_/X VGND VGND VPWR VPWR _482_/X sky130_fd_sc_hd__a21o_2
X_818_ _774_/X _838_/C _817_/X _790_/A VGND VGND VPWR VPWR _818_/Y sky130_fd_sc_hd__a211oi_2
X_749_ _770_/A _749_/B VGND VGND VPWR VPWR _749_/Y sky130_fd_sc_hd__xnor2_2
XTAP_TAPCELL_ROW_20_119 VGND VPWR sky130_fd_sc_hd__tapvpwrvgnd_1
X_465_ _466_/A _481_/B VGND VGND VPWR VPWR _465_/Y sky130_fd_sc_hd__nor2_2
X_534_ _551_/A _534_/B VGND VGND VPWR VPWR _534_/Y sky130_fd_sc_hd__nand2_2
X_603_ _552_/Y _599_/Y _600_/Y _495_/Y _602_/Y VGND VGND VPWR VPWR _603_/X sky130_fd_sc_hd__o221a_2
XFILLER_4_65 VGND VGND VPWR VPWR sky130_fd_sc_hd__fill_1
XTAP_TAPCELL_ROW_9_86 VGND VPWR sky130_fd_sc_hd__tapvpwrvgnd_1
X_448_ _449_/A _888_/B _451_/C VGND VGND VPWR VPWR _855_/A sky130_fd_sc_hd__nor3b_2
X_517_ _668_/A _544_/A _516_/X VGND VGND VPWR VPWR _517_/Y sky130_fd_sc_hd__o21ai_2
XFILLER_10_97 VGND VGND VPWR VPWR sky130_fd_sc_hd__decap_3
XFILLER_19_40 VGND VGND VPWR VPWR sky130_fd_sc_hd__decap_3
X_851_ _843_/A _836_/X _790_/A _829_/Y VGND VGND VPWR VPWR _851_/X sky130_fd_sc_hd__o211a_2
X_782_ _782_/A _782_/B VGND VGND VPWR VPWR _782_/Y sky130_fd_sc_hd__nand2_2
XFILLER_7_87 VGND VGND VPWR VPWR sky130_fd_sc_hd__decap_3
X_834_ _834_/A _834_/B _834_/C _834_/D VGND VGND VPWR VPWR _834_/X sky130_fd_sc_hd__or4_2
X_765_ _870_/A1 _755_/A _776_/A _824_/A _764_/Y VGND VGND VPWR VPWR _765_/X sky130_fd_sc_hd__o221a_2
X_696_ _834_/A _696_/B VGND VGND VPWR VPWR _696_/X sky130_fd_sc_hd__xor2_2
XFILLER_21_144 VGND VGND VPWR VPWR sky130_fd_sc_hd__fill_1
XFILLER_26_19 VGND VGND VPWR VPWR sky130_fd_sc_hd__decap_3
XTAP_TAPCELL_ROW_23_128 VGND VPWR sky130_fd_sc_hd__tapvpwrvgnd_1
XFILLER_16_85 VGND VGND VPWR VPWR sky130_fd_sc_hd__decap_3
XPHY_EDGE_ROW_11_Right_11 VGND VGND VPWR VPWR sky130_fd_sc_hd__decap_3
XPHY_EDGE_ROW_20_Right_20 VGND VGND VPWR VPWR sky130_fd_sc_hd__decap_3
X_481_ _466_/A _481_/B VGND VGND VPWR VPWR _481_/X sky130_fd_sc_hd__and2b_2
X_550_ _431_/Y _520_/B _551_/B _549_/X VGND VGND VPWR VPWR _550_/X sky130_fd_sc_hd__a31o_2
X_817_ _819_/C _802_/X _816_/X VGND VGND VPWR VPWR _817_/X sky130_fd_sc_hd__a21o_2
XFILLER_7_181 VGND VGND VPWR VPWR sky130_fd_sc_hd__fill_1
X_748_ _762_/A1 _744_/Y _747_/X VGND VGND VPWR VPWR _749_/B sky130_fd_sc_hd__a21oi_2
X_679_ _782_/A _671_/X _690_/B _446_/Y VGND VGND VPWR VPWR _679_/X sky130_fd_sc_hd__a22o_2
X_464_ _466_/A _481_/B VGND VGND VPWR VPWR _474_/B sky130_fd_sc_hd__nand2_2
X_533_ _518_/Y _525_/X _519_/Y _842_/S VGND VGND VPWR VPWR _533_/X sky130_fd_sc_hd__a211o_2
X_602_ _607_/B _589_/X _601_/X VGND VGND VPWR VPWR _602_/Y sky130_fd_sc_hd__a21oi_2
XFILLER_13_86 VGND VGND VPWR VPWR sky130_fd_sc_hd__decap_3
XTAP_TAPCELL_ROW_0_56 VGND VPWR sky130_fd_sc_hd__tapvpwrvgnd_1
XTAP_TAPCELL_ROW_9_87 VGND VPWR sky130_fd_sc_hd__tapvpwrvgnd_1
X_447_ _888_/B _451_/C _449_/A VGND VGND VPWR VPWR _447_/X sky130_fd_sc_hd__or3b_2
X_516_ _844_/A _508_/Y _600_/B _885_/B2 _515_/X VGND VGND VPWR VPWR _516_/X sky130_fd_sc_hd__o221a_2
XFILLER_10_32 VGND VGND VPWR VPWR sky130_fd_sc_hd__fill_1
XFILLER_19_96 VGND VGND VPWR VPWR sky130_fd_sc_hd__decap_3
X_850_ _850_/A _855_/B VGND VGND VPWR VPWR _850_/X sky130_fd_sc_hd__or2_2
X_781_ _819_/A _781_/B VGND VGND VPWR VPWR _781_/X sky130_fd_sc_hd__xor2_2
XTAP_TAPCELL_ROW_6_77 VGND VPWR sky130_fd_sc_hd__tapvpwrvgnd_1
XTAP_TAPCELL_ROW_26_137 VGND VPWR sky130_fd_sc_hd__tapvpwrvgnd_1
XFILLER_15_120 VGND VGND VPWR VPWR sky130_fd_sc_hd__decap_3
XFILLER_15_131 VGND VGND VPWR VPWR sky130_fd_sc_hd__fill_1
XFILLER_15_142 VGND VGND VPWR VPWR sky130_fd_sc_hd__fill_1
X_833_ _812_/Y _820_/X _832_/X _777_/X _814_/A VGND VGND VPWR VPWR _836_/A sky130_fd_sc_hd__o221a_2
X_764_ _782_/A _775_/A VGND VGND VPWR VPWR _764_/Y sky130_fd_sc_hd__nand2_2
X_695_ _707_/B _689_/Y _691_/X _694_/X VGND VGND VPWR VPWR _696_/B sky130_fd_sc_hd__o2bb2a_2
XTAP_TAPCELL_ROW_23_129 VGND VPWR sky130_fd_sc_hd__tapvpwrvgnd_1
XFILLER_16_53 VGND VGND VPWR VPWR sky130_fd_sc_hd__decap_3
X_480_ _468_/A _497_/B _465_/Y _474_/B VGND VGND VPWR VPWR _480_/X sky130_fd_sc_hd__o31a_2
X_816_ _799_/B _816_/B VGND VGND VPWR VPWR _816_/X sky130_fd_sc_hd__and2b_2
X_747_ _759_/A _760_/A _759_/B _746_/Y _821_/C1 VGND VGND VPWR VPWR _747_/X sky130_fd_sc_hd__o311a_2
X_678_ _690_/B _678_/B VGND VGND VPWR VPWR _678_/Y sky130_fd_sc_hd__xnor2_2
X_601_ _585_/A _601_/B VGND VGND VPWR VPWR _601_/X sky130_fd_sc_hd__and2b_2
XFILLER_27_85 VGND VGND VPWR VPWR sky130_fd_sc_hd__fill_2
XFILLER_4_141 VGND VGND VPWR VPWR sky130_fd_sc_hd__decap_3
X_463_ _886_/A1 _460_/Y _462_/X VGND VGND VPWR VPWR _463_/Y sky130_fd_sc_hd__o21ai_2
X_532_ _532_/A _549_/B VGND VGND VPWR VPWR _551_/B sky130_fd_sc_hd__xnor2_2
XTAP_TAPCELL_ROW_13_98 VGND VPWR sky130_fd_sc_hd__tapvpwrvgnd_1
XFILLER_1_188 VGND VGND VPWR VPWR sky130_fd_sc_hd__fill_2
XFILLER_8_3 VGND VGND VPWR VPWR sky130_fd_sc_hd__fill_2
XTAP_TAPCELL_ROW_0_57 VGND VPWR sky130_fd_sc_hd__tapvpwrvgnd_1
XTAP_TAPCELL_ROW_9_88 VGND VPWR sky130_fd_sc_hd__tapvpwrvgnd_1
X_446_ _888_/B _451_/C _449_/A VGND VGND VPWR VPWR _446_/Y sky130_fd_sc_hd__nor3b_2
X_515_ _600_/B _513_/X _514_/X VGND VGND VPWR VPWR _515_/X sky130_fd_sc_hd__a21bo_2
XFILLER_1_57 VGND VGND VPWR VPWR sky130_fd_sc_hd__decap_3
XFILLER_27_9 VGND VGND VPWR VPWR sky130_fd_sc_hd__decap_3
X_429_ _439_/A VGND VGND VPWR VPWR _429_/Y sky130_fd_sc_hd__inv_2
XFILLER_10_11 VGND VGND VPWR VPWR sky130_fd_sc_hd__fill_1
XFILLER_10_66 VGND VGND VPWR VPWR sky130_fd_sc_hd__decap_3
XFILLER_10_88 VGND VGND VPWR VPWR sky130_fd_sc_hd__decap_3
XFILLER_19_64 VGND VGND VPWR VPWR sky130_fd_sc_hd__decap_3
Xinput1 A[0] VGND VGND VPWR VPWR _439_/A sky130_fd_sc_hd__clkdlybuf4s25_1
X_780_ _774_/X _779_/Y _790_/A VGND VGND VPWR VPWR _781_/B sky130_fd_sc_hd__mux2_1
XPHY_EDGE_ROW_11_Left_39 VGND VGND VPWR VPWR sky130_fd_sc_hd__decap_3
XPHY_EDGE_ROW_27_Left_55 VGND VGND VPWR VPWR sky130_fd_sc_hd__decap_3
XTAP_TAPCELL_ROW_6_78 VGND VPWR sky130_fd_sc_hd__tapvpwrvgnd_1
XTAP_TAPCELL_ROW_26_138 VGND VPWR sky130_fd_sc_hd__tapvpwrvgnd_1
X_832_ _838_/B _832_/B VGND VGND VPWR VPWR _832_/X sky130_fd_sc_hd__or2_2
X_763_ _776_/A _763_/B VGND VGND VPWR VPWR _763_/X sky130_fd_sc_hd__xor2_2
X_694_ _694_/A _694_/B VGND VGND VPWR VPWR _694_/X sky130_fd_sc_hd__or2_2
XFILLER_21_102 VGND VGND VPWR VPWR sky130_fd_sc_hd__decap_3
XFILLER_21_113 VGND VGND VPWR VPWR sky130_fd_sc_hd__decap_3
XTAP_TAPCELL_ROW_3_68 VGND VPWR sky130_fd_sc_hd__tapvpwrvgnd_1
XPHY_EDGE_ROW_9_Right_9 VGND VGND VPWR VPWR sky130_fd_sc_hd__decap_3
X_815_ _819_/A _819_/B _819_/C VGND VGND VPWR VPWR _838_/C sky130_fd_sc_hd__and3_2
X_746_ _746_/A _746_/B VGND VGND VPWR VPWR _746_/Y sky130_fd_sc_hd__nand2_2
X_677_ _762_/A1 _675_/Y _676_/Y _674_/X VGND VGND VPWR VPWR _678_/B sky130_fd_sc_hd__a31o_2
XPHY_EDGE_ROW_14_Left_42 VGND VGND VPWR VPWR sky130_fd_sc_hd__decap_3
XFILLER_27_20 VGND VGND VPWR VPWR sky130_fd_sc_hd__decap_3
X_462_ _668_/A _498_/A _456_/Y _885_/B2 _461_/Y VGND VGND VPWR VPWR _462_/X sky130_fd_sc_hd__o221a_2
X_531_ _532_/A _549_/B VGND VGND VPWR VPWR _531_/Y sky130_fd_sc_hd__nand2_2
X_600_ _599_/Y _600_/B _600_/C _600_/D VGND VGND VPWR VPWR _600_/Y sky130_fd_sc_hd__nand4b_2
XTAP_TAPCELL_ROW_13_99 VGND VPWR sky130_fd_sc_hd__tapvpwrvgnd_1
X_729_ _742_/B _729_/B VGND VGND VPWR VPWR _759_/B sky130_fd_sc_hd__xnor2_2
XTAP_TAPCELL_ROW_0_58 VGND VPWR sky130_fd_sc_hd__tapvpwrvgnd_1
X_514_ _600_/B _513_/X _795_/A VGND VGND VPWR VPWR _514_/X sky130_fd_sc_hd__o21a_2
X_445_ _483_/A _440_/B _795_/A VGND VGND VPWR VPWR _445_/X sky130_fd_sc_hd__o21a_2
XTAP_TAPCELL_ROW_10_89 VGND VPWR sky130_fd_sc_hd__tapvpwrvgnd_1
Xinput2 A[10] VGND VGND VPWR VPWR _571_/A sky130_fd_sc_hd__clkdlybuf4s25_1
XFILLER_19_43 VGND VGND VPWR VPWR sky130_fd_sc_hd__decap_3
XPHY_EDGE_ROW_2_Left_30 VGND VGND VPWR VPWR sky130_fd_sc_hd__decap_3
XTAP_TAPCELL_ROW_6_79 VGND VPWR sky130_fd_sc_hd__tapvpwrvgnd_1
XFILLER_21_55 VGND VGND VPWR VPWR sky130_fd_sc_hd__fill_1
XFILLER_24_166 VGND VGND VPWR VPWR sky130_fd_sc_hd__fill_2
XTAP_TAPCELL_ROW_26_139 VGND VPWR sky130_fd_sc_hd__tapvpwrvgnd_1
X_831_ _844_/B _831_/B VGND VGND VPWR VPWR _843_/A sky130_fd_sc_hd__or2_2
X_762_ _762_/A1 _760_/Y _775_/B _758_/X VGND VGND VPWR VPWR _763_/B sky130_fd_sc_hd__o31a_2
X_693_ _690_/B _676_/Y _692_/Y VGND VGND VPWR VPWR _694_/B sky130_fd_sc_hd__o21ai_2
XFILLER_15_111 VGND VGND VPWR VPWR sky130_fd_sc_hd__fill_1
XFILLER_7_46 VGND VGND VPWR VPWR sky130_fd_sc_hd__decap_3
XFILLER_12_158 VGND VGND VPWR VPWR sky130_fd_sc_hd__decap_3
Xinput60 B[5] VGND VGND VPWR VPWR _521_/B sky130_fd_sc_hd__clkdlybuf4s25_1
XTAP_TAPCELL_ROW_3_69 VGND VPWR sky130_fd_sc_hd__tapvpwrvgnd_1
X_814_ _814_/A _814_/B VGND VGND VPWR VPWR _838_/B sky130_fd_sc_hd__nand2_2
X_745_ _731_/B _714_/B _742_/B _729_/B VGND VGND VPWR VPWR _746_/B sky130_fd_sc_hd__a22o_2
X_676_ _654_/B _676_/B VGND VGND VPWR VPWR _676_/Y sky130_fd_sc_hd__nand2b_2
XFILLER_4_36 VGND VGND VPWR VPWR sky130_fd_sc_hd__fill_1
X_461_ _456_/A _469_/B _782_/A VGND VGND VPWR VPWR _461_/Y sky130_fd_sc_hd__o21ai_2
X_530_ _844_/A _519_/Y _529_/X VGND VGND VPWR VPWR _530_/Y sky130_fd_sc_hd__o21ai_2
X_728_ _742_/B _729_/B VGND VGND VPWR VPWR _746_/A sky130_fd_sc_hd__or2_2
X_659_ _638_/X _646_/A _637_/X VGND VGND VPWR VPWR _659_/Y sky130_fd_sc_hd__a21oi_2
XFILLER_13_89 VGND VGND VPWR VPWR sky130_fd_sc_hd__decap_3
XFILLER_1_102 VGND VGND VPWR VPWR sky130_fd_sc_hd__fill_2
XFILLER_1_113 VGND VGND VPWR VPWR sky130_fd_sc_hd__fill_1
XTAP_TAPCELL_ROW_0_59 VGND VPWR sky130_fd_sc_hd__tapvpwrvgnd_1
X_444_ _449_/A _451_/C VGND VGND VPWR VPWR _808_/A sky130_fd_sc_hd__nor2_2
X_513_ _510_/Y _511_/Y _512_/X _694_/A VGND VGND VPWR VPWR _513_/X sky130_fd_sc_hd__a22o_2
XFILLER_24_11 VGND VGND VPWR VPWR sky130_fd_sc_hd__decap_3
XPHY_EDGE_ROW_18_Right_18 VGND VGND VPWR VPWR sky130_fd_sc_hd__decap_3
XPHY_EDGE_ROW_27_Right_27 VGND VGND VPWR VPWR sky130_fd_sc_hd__decap_3
Xinput3 A[11] VGND VGND VPWR VPWR _585_/A sky130_fd_sc_hd__clkdlybuf4s25_1
XFILLER_19_11 VGND VGND VPWR VPWR sky130_fd_sc_hd__fill_2
XFILLER_18_131 VGND VGND VPWR VPWR sky130_fd_sc_hd__decap_3
XFILLER_21_78 VGND VGND VPWR VPWR sky130_fd_sc_hd__decap_3
XFILLER_2_80 VGND VGND VPWR VPWR sky130_fd_sc_hd__fill_1
X_830_ _844_/B _831_/B VGND VGND VPWR VPWR _830_/Y sky130_fd_sc_hd__nor2_2
X_761_ _746_/A _739_/X _746_/B _738_/X VGND VGND VPWR VPWR _775_/B sky130_fd_sc_hd__a31o_2
XFILLER_15_167 VGND VGND VPWR VPWR sky130_fd_sc_hd__fill_1
XFILLER_7_69 VGND VGND VPWR VPWR sky130_fd_sc_hd__decap_3
X_692_ _672_/B _692_/B VGND VGND VPWR VPWR _692_/Y sky130_fd_sc_hd__nand2b_2
XFILLER_21_126 VGND VGND VPWR VPWR sky130_fd_sc_hd__decap_3
XFILLER_21_159 VGND VGND VPWR VPWR sky130_fd_sc_hd__decap_3
Xinput50 B[25] VGND VGND VPWR VPWR _801_/B sky130_fd_sc_hd__clkdlybuf4s25_1
Xinput61 B[6] VGND VGND VPWR VPWR _520_/B sky130_fd_sc_hd__clkdlybuf4s25_1
XFILLER_12_115 VGND VGND VPWR VPWR sky130_fd_sc_hd__fill_1
XPHY_EDGE_ROW_0_Right_0 VGND VGND VPWR VPWR sky130_fd_sc_hd__decap_3
X_813_ _837_/B _813_/B VGND VGND VPWR VPWR _814_/B sky130_fd_sc_hd__or2_2
X_744_ _721_/X _770_/B _743_/X VGND VGND VPWR VPWR _744_/Y sky130_fd_sc_hd__a21oi_2
X_675_ _690_/A _691_/A VGND VGND VPWR VPWR _675_/Y sky130_fd_sc_hd__nand2b_2
XFILLER_27_55 VGND VGND VPWR VPWR sky130_fd_sc_hd__fill_1
X_460_ _497_/B _460_/B VGND VGND VPWR VPWR _460_/Y sky130_fd_sc_hd__xnor2_2
XFILLER_4_144 VGND VGND VPWR VPWR sky130_fd_sc_hd__fill_1
X_589_ _571_/Y _577_/X _588_/X VGND VGND VPWR VPWR _589_/X sky130_fd_sc_hd__a21o_2
X_727_ _742_/B _729_/B VGND VGND VPWR VPWR _727_/Y sky130_fd_sc_hd__nand2_2
X_658_ _658_/A _658_/B _658_/C _658_/D VGND VGND VPWR VPWR _658_/X sky130_fd_sc_hd__or4_2
X_443_ _449_/A _451_/C VGND VGND VPWR VPWR _443_/X sky130_fd_sc_hd__or2_2
X_512_ _600_/C _501_/B _490_/Y VGND VGND VPWR VPWR _512_/X sky130_fd_sc_hd__o21a_2
XFILLER_24_34 VGND VGND VPWR VPWR sky130_fd_sc_hd__fill_1
XFILLER_24_78 VGND VGND VPWR VPWR sky130_fd_sc_hd__fill_1
Xinput4 A[12] VGND VGND VPWR VPWR _598_/A sky130_fd_sc_hd__clkdlybuf4s25_1
XFILLER_10_25 VGND VGND VPWR VPWR sky130_fd_sc_hd__decap_3
XFILLER_10_69 VGND VGND VPWR VPWR sky130_fd_sc_hd__decap_3
XFILLER_19_67 VGND VGND VPWR VPWR sky130_fd_sc_hd__decap_3
XFILLER_19_78 VGND VGND VPWR VPWR sky130_fd_sc_hd__fill_2
XFILLER_27_165 VGND VGND VPWR VPWR sky130_fd_sc_hd__decap_3
XFILLER_21_57 VGND VGND VPWR VPWR sky130_fd_sc_hd__fill_1
XFILLER_2_92 VGND VGND VPWR VPWR sky130_fd_sc_hd__fill_2
X_760_ _760_/A _776_/B VGND VGND VPWR VPWR _760_/Y sky130_fd_sc_hd__nor2_2
X_691_ _691_/A _720_/B VGND VGND VPWR VPWR _691_/X sky130_fd_sc_hd__and2_2
XFILLER_21_105 VGND VGND VPWR VPWR sky130_fd_sc_hd__fill_1
XFILLER_21_116 VGND VGND VPWR VPWR sky130_fd_sc_hd__decap_3
XTAP_TAPCELL_ROW_7_80 VGND VPWR sky130_fd_sc_hd__tapvpwrvgnd_1
Xinput40 B[16] VGND VGND VPWR VPWR _676_/B sky130_fd_sc_hd__clkdlybuf4s25_1
Xinput51 B[26] VGND VGND VPWR VPWR _816_/B sky130_fd_sc_hd__clkdlybuf4s25_1
Xinput62 B[7] VGND VGND VPWR VPWR _549_/B sky130_fd_sc_hd__clkdlybuf4s25_1
X_889_ _875_/A _881_/B _888_/X VGND VGND VPWR VPWR _889_/Y sky130_fd_sc_hd__a21oi_2
XFILLER_16_68 VGND VGND VPWR VPWR sky130_fd_sc_hd__decap_3
X_812_ _837_/B _813_/B VGND VGND VPWR VPWR _812_/Y sky130_fd_sc_hd__nor2_2
X_743_ _759_/B _731_/X _742_/X VGND VGND VPWR VPWR _743_/X sky130_fd_sc_hd__a21o_2
X_674_ _674_/A _674_/B VGND VGND VPWR VPWR _674_/X sky130_fd_sc_hd__and2_2
XTAP_TAPCELL_ROW_13_100 VGND VPWR sky130_fd_sc_hd__tapvpwrvgnd_1
XFILLER_27_12 VGND VGND VPWR VPWR sky130_fd_sc_hd__decap_3
XFILLER_27_23 VGND VGND VPWR VPWR sky130_fd_sc_hd__decap_3
X_588_ _571_/A _588_/B VGND VGND VPWR VPWR _588_/X sky130_fd_sc_hd__and2b_2
X_726_ _766_/A1 _723_/X _725_/X VGND VGND VPWR VPWR _726_/Y sky130_fd_sc_hd__o21ai_2
X_657_ _658_/B _658_/C _658_/D VGND VGND VPWR VPWR _657_/X sky130_fd_sc_hd__or3_2
XPHY_EDGE_ROW_18_Left_46 VGND VGND VPWR VPWR sky130_fd_sc_hd__decap_3
X_442_ _449_/A _451_/C _888_/B VGND VGND VPWR VPWR _442_/X sky130_fd_sc_hd__or3b_2
X_511_ _430_/Y _491_/B _694_/A VGND VGND VPWR VPWR _511_/Y sky130_fd_sc_hd__a21oi_2
XFILLER_5_70 VGND VGND VPWR VPWR sky130_fd_sc_hd__fill_2
X_709_ _834_/C _709_/B VGND VGND VPWR VPWR _709_/Y sky130_fd_sc_hd__xnor2_2
Xinput5 A[13] VGND VGND VPWR VPWR _615_/A sky130_fd_sc_hd__clkdlybuf4s25_1
XPHY_EDGE_ROW_6_Left_34 VGND VGND VPWR VPWR sky130_fd_sc_hd__decap_3
X_690_ _690_/A _690_/B VGND VGND VPWR VPWR _720_/B sky130_fd_sc_hd__nor2_2
XFILLER_11_80 VGND VGND VPWR VPWR sky130_fd_sc_hd__decap_3
XTAP_TAPCELL_ROW_7_81 VGND VPWR sky130_fd_sc_hd__tapvpwrvgnd_1
Xinput30 A[7] VGND VGND VPWR VPWR _532_/A sky130_fd_sc_hd__clkdlybuf4s25_1
Xinput41 B[17] VGND VGND VPWR VPWR _692_/B sky130_fd_sc_hd__clkdlybuf4s25_1
Xinput52 B[27] VGND VGND VPWR VPWR _837_/B sky130_fd_sc_hd__clkdlybuf4s25_1
Xinput63 B[8] VGND VGND VPWR VPWR _564_/B sky130_fd_sc_hd__clkdlybuf4s25_1
X_888_ _888_/A _888_/B _888_/C _884_/B VGND VGND VPWR VPWR _888_/X sky130_fd_sc_hd__or4b_2
X_811_ _837_/B _813_/B VGND VGND VPWR VPWR _814_/A sky130_fd_sc_hd__nand2_2
X_742_ _729_/B _742_/B VGND VGND VPWR VPWR _742_/X sky130_fd_sc_hd__and2b_2
X_673_ _655_/A _662_/Y _762_/A1 VGND VGND VPWR VPWR _674_/B sky130_fd_sc_hd__a21oi_2
XFILLER_27_57 VGND VGND VPWR VPWR sky130_fd_sc_hd__decap_3
XFILLER_8_81 VGND VGND VPWR VPWR sky130_fd_sc_hd__decap_3
XFILLER_4_124 VGND VGND VPWR VPWR sky130_fd_sc_hd__fill_2
XFILLER_4_168 VGND VGND VPWR VPWR sky130_fd_sc_hd__fill_1
X_587_ _540_/Y _599_/B _571_/Y _586_/Y _570_/Y VGND VGND VPWR VPWR _587_/X sky130_fd_sc_hd__o311a_2
X_725_ _736_/A1 _713_/Y _759_/A _824_/A _724_/Y VGND VGND VPWR VPWR _725_/X sky130_fd_sc_hd__o221a_2
X_656_ _663_/A _663_/B _663_/C _663_/D VGND VGND VPWR VPWR _658_/D sky130_fd_sc_hd__or4_2
XTAP_TAPCELL_ROW_4_71 VGND VPWR sky130_fd_sc_hd__tapvpwrvgnd_1
X_441_ _449_/A _451_/C _888_/B VGND VGND VPWR VPWR _881_/A sky130_fd_sc_hd__nor3b_2
X_510_ _510_/A _510_/B VGND VGND VPWR VPWR _510_/Y sky130_fd_sc_hd__nand2_2
X_708_ _717_/A _706_/X _707_/Y _705_/X VGND VGND VPWR VPWR _709_/B sky130_fd_sc_hd__o31a_2
X_639_ _639_/A _639_/B VGND VGND VPWR VPWR _663_/D sky130_fd_sc_hd__xnor2_2
XFILLER_24_14 VGND VGND VPWR VPWR sky130_fd_sc_hd__fill_1
XFILLER_24_47 VGND VGND VPWR VPWR sky130_fd_sc_hd__fill_1
XFILLER_14_91 VGND VGND VPWR VPWR sky130_fd_sc_hd__decap_3
Xinput6 A[14] VGND VGND VPWR VPWR _625_/A sky130_fd_sc_hd__clkdlybuf4s25_1
XFILLER_18_134 VGND VGND VPWR VPWR sky130_fd_sc_hd__fill_1
XPHY_EDGE_ROW_14_Right_14 VGND VGND VPWR VPWR sky130_fd_sc_hd__decap_3
XPHY_EDGE_ROW_23_Right_23 VGND VGND VPWR VPWR sky130_fd_sc_hd__decap_3
XFILLER_24_126 VGND VGND VPWR VPWR sky130_fd_sc_hd__fill_2
XPHY_EDGE_ROW_22_Left_50 VGND VGND VPWR VPWR sky130_fd_sc_hd__decap_3
XTAP_TAPCELL_ROW_11_92 VGND VPWR sky130_fd_sc_hd__tapvpwrvgnd_1
XFILLER_11_92 VGND VGND VPWR VPWR sky130_fd_sc_hd__decap_3
XFILLER_21_129 VGND VGND VPWR VPWR sky130_fd_sc_hd__decap_3
XTAP_TAPCELL_ROW_7_82 VGND VPWR sky130_fd_sc_hd__tapvpwrvgnd_1
Xinput31 A[8] VGND VGND VPWR VPWR _541_/A sky130_fd_sc_hd__clkdlybuf4s25_1
Xinput20 A[27] VGND VGND VPWR VPWR _813_/B sky130_fd_sc_hd__clkdlybuf4s25_1
X_887_ _876_/Y _877_/X _879_/X _436_/Y _874_/A VGND VGND VPWR VPWR _887_/Y sky130_fd_sc_hd__o32ai_2
Xinput42 B[18] VGND VGND VPWR VPWR _703_/B sky130_fd_sc_hd__clkdlybuf4s25_1
Xinput53 B[28] VGND VGND VPWR VPWR _829_/B sky130_fd_sc_hd__clkdlybuf4s25_1
Xinput64 B[9] VGND VGND VPWR VPWR _576_/B sky130_fd_sc_hd__clkdlybuf4s25_1
XFILLER_22_80 VGND VGND VPWR VPWR sky130_fd_sc_hd__decap_3
XFILLER_22_91 VGND VGND VPWR VPWR sky130_fd_sc_hd__fill_2
XFILLER_7_144 VGND VGND VPWR VPWR sky130_fd_sc_hd__decap_3
XFILLER_7_166 VGND VGND VPWR VPWR sky130_fd_sc_hd__fill_2
X_810_ _871_/A1 _819_/C _808_/Y _809_/X VGND VGND VPWR VPWR _810_/Y sky130_fd_sc_hd__o211ai_2
X_741_ _759_/A _759_/B VGND VGND VPWR VPWR _770_/B sky130_fd_sc_hd__and2_2
X_672_ _692_/B _672_/B VGND VGND VPWR VPWR _690_/B sky130_fd_sc_hd__xor2_2
XFILLER_8_71 VGND VGND VPWR VPWR sky130_fd_sc_hd__decap_3
XPHY_EDGE_ROW_4_Right_4 VGND VGND VPWR VPWR sky130_fd_sc_hd__decap_3
XFILLER_4_18 VGND VGND VPWR VPWR sky130_fd_sc_hd__decap_3
X_724_ _731_/B _714_/B _724_/B1 VGND VGND VPWR VPWR _724_/Y sky130_fd_sc_hd__o21ai_2
XTAP_TAPCELL_ROW_4_72 VGND VPWR sky130_fd_sc_hd__tapvpwrvgnd_1
X_586_ _571_/A _588_/B _560_/A _576_/B VGND VGND VPWR VPWR _586_/Y sky130_fd_sc_hd__o211ai_2
X_655_ _655_/A _674_/A VGND VGND VPWR VPWR _690_/A sky130_fd_sc_hd__and2_2
XFILLER_13_16 VGND VGND VPWR VPWR sky130_fd_sc_hd__fill_1
X_440_ _483_/A _440_/B VGND VGND VPWR VPWR _497_/A sky130_fd_sc_hd__nand2_2
X_569_ _766_/A1 _566_/X _568_/X VGND VGND VPWR VPWR _569_/Y sky130_fd_sc_hd__o21ai_2
X_707_ _834_/A _707_/B VGND VGND VPWR VPWR _707_/Y sky130_fd_sc_hd__nor2_2
X_638_ _639_/A _639_/B VGND VGND VPWR VPWR _638_/X sky130_fd_sc_hd__or2_2
XFILLER_5_50 VGND VGND VPWR VPWR sky130_fd_sc_hd__fill_1
XTAP_TAPCELL_ROW_1_62 VGND VPWR sky130_fd_sc_hd__tapvpwrvgnd_1
Xinput7 A[15] VGND VGND VPWR VPWR _639_/A sky130_fd_sc_hd__clkdlybuf4s25_1
XFILLER_27_113 VGND VGND VPWR VPWR sky130_fd_sc_hd__decap_3
XFILLER_4_3 VGND VGND VPWR VPWR sky130_fd_sc_hd__fill_1
XFILLER_18_157 VGND VGND VPWR VPWR sky130_fd_sc_hd__fill_1
XFILLER_2_51 VGND VGND VPWR VPWR sky130_fd_sc_hd__fill_1
XTAP_TAPCELL_ROW_11_93 VGND VPWR sky130_fd_sc_hd__tapvpwrvgnd_1
XFILLER_11_60 VGND VGND VPWR VPWR sky130_fd_sc_hd__fill_1
X_886_ _886_/A1 _883_/Y _885_/X VGND VGND VPWR VPWR _886_/Y sky130_fd_sc_hd__o21ai_2
XFILLER_16_27 VGND VGND VPWR VPWR sky130_fd_sc_hd__fill_1
XFILLER_20_141 VGND VGND VPWR VPWR sky130_fd_sc_hd__fill_2
XFILLER_21_119 VGND VGND VPWR VPWR sky130_fd_sc_hd__fill_2
XTAP_TAPCELL_ROW_22_125 VGND VPWR sky130_fd_sc_hd__tapvpwrvgnd_1
Xinput21 A[28] VGND VGND VPWR VPWR _829_/A sky130_fd_sc_hd__clkdlybuf4s25_1
Xinput32 A[9] VGND VGND VPWR VPWR _560_/A sky130_fd_sc_hd__clkdlybuf4s25_1
Xinput43 B[19] VGND VGND VPWR VPWR _718_/B sky130_fd_sc_hd__clkdlybuf4s25_1
Xinput54 B[29] VGND VGND VPWR VPWR _864_/B sky130_fd_sc_hd__clkdlybuf4s25_1
Xinput65 opCode[0] VGND VGND VPWR VPWR _888_/B sky130_fd_sc_hd__clkdlybuf4s25_1
Xinput10 A[18] VGND VGND VPWR VPWR _684_/B sky130_fd_sc_hd__clkdlybuf4s25_1
XFILLER_11_174 VGND VGND VPWR VPWR sky130_fd_sc_hd__fill_1
X_740_ _756_/B _740_/B VGND VGND VPWR VPWR _770_/A sky130_fd_sc_hd__xnor2_2
X_671_ _692_/B _672_/B VGND VGND VPWR VPWR _671_/X sky130_fd_sc_hd__or2_2
X_869_ _868_/A _868_/B _808_/A VGND VGND VPWR VPWR _869_/X sky130_fd_sc_hd__o21a_2
XFILLER_27_26 VGND VGND VPWR VPWR sky130_fd_sc_hd__fill_2
XFILLER_17_81 VGND VGND VPWR VPWR sky130_fd_sc_hd__fill_2
XTAP_TAPCELL_ROW_4_73 VGND VPWR sky130_fd_sc_hd__tapvpwrvgnd_1
X_585_ _585_/A _601_/B VGND VGND VPWR VPWR _607_/B sky130_fd_sc_hd__xnor2_2
X_723_ _759_/A _723_/B VGND VGND VPWR VPWR _723_/X sky130_fd_sc_hd__xor2_2
X_654_ _676_/B _654_/B VGND VGND VPWR VPWR _674_/A sky130_fd_sc_hd__nand2_2
XFILLER_13_39 VGND VGND VPWR VPWR sky130_fd_sc_hd__decap_3
X_706_ _671_/X _684_/X _686_/X _697_/B VGND VGND VPWR VPWR _706_/X sky130_fd_sc_hd__a31o_2
X_637_ _639_/A _639_/B VGND VGND VPWR VPWR _637_/X sky130_fd_sc_hd__and2_2
X_499_ _479_/B _480_/X _498_/X _487_/B VGND VGND VPWR VPWR _500_/B sky130_fd_sc_hd__a31o_2
X_568_ _736_/A1 _559_/Y _566_/A _710_/A _567_/Y VGND VGND VPWR VPWR _568_/X sky130_fd_sc_hd__o221a_2
XFILLER_14_71 VGND VGND VPWR VPWR sky130_fd_sc_hd__fill_2
XFILLER_14_82 VGND VGND VPWR VPWR sky130_fd_sc_hd__fill_2
XTAP_TAPCELL_ROW_1_63 VGND VPWR sky130_fd_sc_hd__tapvpwrvgnd_1
Xinput8 A[16] VGND VGND VPWR VPWR _654_/B sky130_fd_sc_hd__clkdlybuf4s25_1
XFILLER_10_29 VGND VGND VPWR VPWR sky130_fd_sc_hd__decap_3
XFILLER_27_103 VGND VGND VPWR VPWR sky130_fd_sc_hd__fill_1
XFILLER_11_83 VGND VGND VPWR VPWR sky130_fd_sc_hd__decap_3
XTAP_TAPCELL_ROW_11_94 VGND VPWR sky130_fd_sc_hd__tapvpwrvgnd_1
XTAP_TAPCELL_ROW_25_134 VGND VPWR sky130_fd_sc_hd__tapvpwrvgnd_1
X_885_ _668_/A _875_/A _883_/A _885_/B2 _884_/Y VGND VGND VPWR VPWR _885_/X sky130_fd_sc_hd__o221a_2
Xinput22 A[29] VGND VGND VPWR VPWR _848_/A sky130_fd_sc_hd__clkdlybuf4s25_1
Xinput33 B[0] VGND VGND VPWR VPWR _439_/B sky130_fd_sc_hd__clkdlybuf4s25_1
Xinput44 B[1] VGND VGND VPWR VPWR _469_/B sky130_fd_sc_hd__clkdlybuf4s25_1
Xinput55 B[2] VGND VGND VPWR VPWR _481_/B sky130_fd_sc_hd__clkdlybuf4s25_1
Xinput66 opCode[1] VGND VGND VPWR VPWR _888_/C sky130_fd_sc_hd__clkdlybuf4s25_1
Xinput11 A[19] VGND VGND VPWR VPWR _701_/B sky130_fd_sc_hd__clkdlybuf4s25_1
XFILLER_20_164 VGND VGND VPWR VPWR sky130_fd_sc_hd__decap_3
XTAP_TAPCELL_ROW_22_126 VGND VPWR sky130_fd_sc_hd__tapvpwrvgnd_1
X_670_ _795_/A _667_/X _669_/X VGND VGND VPWR VPWR _670_/X sky130_fd_sc_hd__a21o_2
XFILLER_11_120 VGND VGND VPWR VPWR sky130_fd_sc_hd__fill_2
XFILLER_7_113 VGND VGND VPWR VPWR sky130_fd_sc_hd__fill_2
X_868_ _868_/A _868_/B VGND VGND VPWR VPWR _868_/Y sky130_fd_sc_hd__nand2_2
X_799_ _816_/B _799_/B VGND VGND VPWR VPWR _800_/B sky130_fd_sc_hd__nand2_2
XFILLER_17_60 VGND VGND VPWR VPWR sky130_fd_sc_hd__decap_3
X_584_ _585_/A _601_/B VGND VGND VPWR VPWR _584_/Y sky130_fd_sc_hd__nand2_2
X_722_ _717_/A _721_/X _717_/Y VGND VGND VPWR VPWR _723_/B sky130_fd_sc_hd__a21o_2
X_653_ _676_/B _654_/B VGND VGND VPWR VPWR _655_/A sky130_fd_sc_hd__or2_2
X_498_ _498_/A _498_/B VGND VGND VPWR VPWR _498_/X sky130_fd_sc_hd__or2_2
X_567_ _560_/A _576_/B _724_/B1 VGND VGND VPWR VPWR _567_/Y sky130_fd_sc_hd__o21ai_2
X_636_ _766_/A1 _633_/Y _635_/X VGND VGND VPWR VPWR _636_/Y sky130_fd_sc_hd__o21ai_2
X_705_ _834_/A _691_/X _704_/X _821_/C1 VGND VGND VPWR VPWR _705_/X sky130_fd_sc_hd__a211o_2
XFILLER_14_94 VGND VGND VPWR VPWR sky130_fd_sc_hd__decap_3
XTAP_TAPCELL_ROW_1_64 VGND VPWR sky130_fd_sc_hd__tapvpwrvgnd_1
X_619_ _717_/A _616_/Y _617_/Y _618_/X VGND VGND VPWR VPWR _620_/B sky130_fd_sc_hd__a31o_2
Xinput9 A[17] VGND VGND VPWR VPWR _672_/B sky130_fd_sc_hd__clkdlybuf4s25_1
XFILLER_18_115 VGND VGND VPWR VPWR sky130_fd_sc_hd__decap_3
XFILLER_17_181 VGND VGND VPWR VPWR sky130_fd_sc_hd__fill_1
XPHY_EDGE_ROW_10_Right_10 VGND VGND VPWR VPWR sky130_fd_sc_hd__decap_3
XFILLER_11_95 VGND VGND VPWR VPWR sky130_fd_sc_hd__decap_3
XTAP_TAPCELL_ROW_25_135 VGND VPWR sky130_fd_sc_hd__tapvpwrvgnd_1
XPHY_EDGE_ROW_10_Left_38 VGND VGND VPWR VPWR sky130_fd_sc_hd__decap_3
XPHY_EDGE_ROW_26_Left_54 VGND VGND VPWR VPWR sky130_fd_sc_hd__decap_3
Xinput23 A[2] VGND VGND VPWR VPWR _466_/A sky130_fd_sc_hd__clkdlybuf4s25_1
Xinput34 B[10] VGND VGND VPWR VPWR _588_/B sky130_fd_sc_hd__clkdlybuf4s25_1
Xinput45 B[20] VGND VGND VPWR VPWR _731_/B sky130_fd_sc_hd__clkdlybuf4s25_1
Xinput56 B[30] VGND VGND VPWR VPWR _878_/B sky130_fd_sc_hd__clkdlybuf4s25_1
Xinput67 opCode[2] VGND VGND VPWR VPWR _888_/A sky130_fd_sc_hd__clkdlybuf4s25_1
Xinput12 A[1] VGND VGND VPWR VPWR _456_/A sky130_fd_sc_hd__clkdlybuf4s25_1
X_884_ _884_/A _884_/B VGND VGND VPWR VPWR _884_/Y sky130_fd_sc_hd__nand2_2
XFILLER_20_110 VGND VGND VPWR VPWR sky130_fd_sc_hd__decap_3
XTAP_TAPCELL_ROW_22_127 VGND VPWR sky130_fd_sc_hd__tapvpwrvgnd_1
XFILLER_22_83 VGND VGND VPWR VPWR sky130_fd_sc_hd__fill_1
XFILLER_7_147 VGND VGND VPWR VPWR sky130_fd_sc_hd__fill_1
XFILLER_7_169 VGND VGND VPWR VPWR sky130_fd_sc_hd__decap_3
X_867_ _863_/X _866_/X _881_/A VGND VGND VPWR VPWR _868_/B sky130_fd_sc_hd__mux2_1
X_798_ _816_/B _799_/B VGND VGND VPWR VPWR _798_/Y sky130_fd_sc_hd__nor2_2
XFILLER_8_85 VGND VGND VPWR VPWR sky130_fd_sc_hd__fill_1
X_583_ _585_/A _601_/B VGND VGND VPWR VPWR _583_/Y sky130_fd_sc_hd__nor2_2
X_721_ _691_/A _773_/A _719_/X VGND VGND VPWR VPWR _721_/X sky130_fd_sc_hd__a21o_2
X_652_ _795_/A _649_/Y _651_/X VGND VGND VPWR VPWR _652_/X sky130_fd_sc_hd__a21o_2
XPHY_EDGE_ROW_8_Right_8 VGND VGND VPWR VPWR sky130_fd_sc_hd__decap_3
XPHY_EDGE_ROW_13_Left_41 VGND VGND VPWR VPWR sky130_fd_sc_hd__decap_3
XFILLER_0_120 VGND VGND VPWR VPWR sky130_fd_sc_hd__decap_3
X_497_ _497_/A _497_/B _498_/B _497_/D VGND VGND VPWR VPWR _500_/A sky130_fd_sc_hd__or4_2
X_566_ _566_/A _566_/B VGND VGND VPWR VPWR _566_/X sky130_fd_sc_hd__xor2_2
X_635_ _736_/A1 _624_/Y _625_/Y _710_/A _634_/Y VGND VGND VPWR VPWR _635_/X sky130_fd_sc_hd__o221a_2
X_704_ _834_/A _694_/B _703_/X VGND VGND VPWR VPWR _704_/X sky130_fd_sc_hd__a21o_2
XFILLER_14_62 VGND VGND VPWR VPWR sky130_fd_sc_hd__fill_2
XFILLER_27_116 VGND VGND VPWR VPWR sky130_fd_sc_hd__fill_1
X_549_ _532_/A _549_/B VGND VGND VPWR VPWR _549_/X sky130_fd_sc_hd__and2b_2
X_618_ _663_/A _626_/B _609_/S _597_/Y VGND VGND VPWR VPWR _618_/X sky130_fd_sc_hd__o211a_2
XFILLER_23_141 VGND VGND VPWR VPWR sky130_fd_sc_hd__fill_1
XTAP_TAPCELL_ROW_25_136 VGND VPWR sky130_fd_sc_hd__tapvpwrvgnd_1
Xoutput100 _558_/Y VGND VGND VPWR VPWR y[8] sky130_fd_sc_hd__clkdlybuf4s25_1
Xinput24 A[30] VGND VGND VPWR VPWR _877_/B sky130_fd_sc_hd__clkdlybuf4s25_1
Xinput35 B[11] VGND VGND VPWR VPWR _601_/B sky130_fd_sc_hd__clkdlybuf4s25_1
Xinput46 B[21] VGND VGND VPWR VPWR _742_/B sky130_fd_sc_hd__clkdlybuf4s25_1
Xinput57 B[31] VGND VGND VPWR VPWR _874_/B sky130_fd_sc_hd__clkdlybuf4s25_1
Xinput68 statusIn[0] VGND VGND VPWR VPWR _483_/A sky130_fd_sc_hd__clkdlybuf4s25_1
Xinput13 A[20] VGND VGND VPWR VPWR _714_/B sky130_fd_sc_hd__clkdlybuf4s25_1
X_883_ _883_/A _883_/B VGND VGND VPWR VPWR _883_/Y sky130_fd_sc_hd__xnor2_2
XFILLER_11_111 VGND VGND VPWR VPWR sky130_fd_sc_hd__fill_1
XFILLER_11_188 VGND VGND VPWR VPWR sky130_fd_sc_hd__fill_2
X_866_ _830_/Y _841_/Y _849_/Y _865_/X VGND VGND VPWR VPWR _866_/X sky130_fd_sc_hd__o31a_2
XFILLER_27_29 VGND VGND VPWR VPWR sky130_fd_sc_hd__fill_2
X_797_ _871_/A1 _819_/B _795_/Y _796_/X VGND VGND VPWR VPWR _797_/Y sky130_fd_sc_hd__o211ai_2
X_582_ _736_/A1 _570_/Y _580_/Y _581_/X VGND VGND VPWR VPWR _582_/Y sky130_fd_sc_hd__o211ai_2
X_720_ _834_/A _720_/B _834_/C VGND VGND VPWR VPWR _773_/A sky130_fd_sc_hd__and3_2
X_651_ _751_/A1 _637_/X _638_/X _724_/B1 _650_/Y VGND VGND VPWR VPWR _651_/X sky130_fd_sc_hd__a221o_2
X_849_ _850_/A _855_/B VGND VGND VPWR VPWR _849_/Y sky130_fd_sc_hd__nor2_2
X_496_ _497_/D _482_/X _492_/X _494_/X VGND VGND VPWR VPWR _510_/B sky130_fd_sc_hd__a211o_2
X_565_ _609_/S _575_/B _564_/X _562_/X VGND VGND VPWR VPWR _566_/B sky130_fd_sc_hd__o31a_2
X_634_ _625_/A _642_/B _724_/B1 VGND VGND VPWR VPWR _634_/Y sky130_fd_sc_hd__o21ai_2
X_703_ _684_/B _703_/B VGND VGND VPWR VPWR _703_/X sky130_fd_sc_hd__and2b_2
XFILLER_14_85 VGND VGND VPWR VPWR sky130_fd_sc_hd__decap_3
X_479_ _487_/B _479_/B VGND VGND VPWR VPWR _497_/D sky130_fd_sc_hd__nand2b_2
X_548_ _609_/S _573_/B VGND VGND VPWR VPWR _548_/Y sky130_fd_sc_hd__nand2_2
X_617_ _598_/A _629_/A VGND VGND VPWR VPWR _617_/Y sky130_fd_sc_hd__nand2b_2
XFILLER_18_128 VGND VGND VPWR VPWR sky130_fd_sc_hd__decap_3
Xoutput101 _569_/Y VGND VGND VPWR VPWR y[9] sky130_fd_sc_hd__clkdlybuf4s25_1
XFILLER_11_86 VGND VGND VPWR VPWR sky130_fd_sc_hd__decap_3
XFILLER_14_131 VGND VGND VPWR VPWR sky130_fd_sc_hd__fill_2
Xinput25 A[31] VGND VGND VPWR VPWR _874_/A sky130_fd_sc_hd__clkdlybuf4s25_1
Xinput36 B[12] VGND VGND VPWR VPWR _629_/A sky130_fd_sc_hd__clkdlybuf4s25_1
Xinput14 A[21] VGND VGND VPWR VPWR _729_/B sky130_fd_sc_hd__clkdlybuf4s25_1
X_882_ _790_/A _877_/X _879_/X _881_/X VGND VGND VPWR VPWR _883_/B sky130_fd_sc_hd__o31a_2
Xinput47 B[22] VGND VGND VPWR VPWR _756_/B sky130_fd_sc_hd__clkdlybuf4s25_1
Xinput58 B[3] VGND VGND VPWR VPWR _492_/B sky130_fd_sc_hd__clkdlybuf4s25_1
XFILLER_11_101 VGND VGND VPWR VPWR sky130_fd_sc_hd__fill_1
X_865_ _829_/A _435_/Y _849_/Y _864_/Y VGND VGND VPWR VPWR _865_/X sky130_fd_sc_hd__o31a_2
X_796_ _870_/A1 _788_/A _786_/Y _844_/A VGND VGND VPWR VPWR _796_/X sky130_fd_sc_hd__o22a_2
X_650_ _710_/A _663_/D VGND VGND VPWR VPWR _650_/Y sky130_fd_sc_hd__nor2_2
X_581_ _710_/A _607_/A _579_/X _766_/A1 VGND VGND VPWR VPWR _581_/X sky130_fd_sc_hd__o22a_2
X_848_ _848_/A _864_/B VGND VGND VPWR VPWR _855_/B sky130_fd_sc_hd__and2_2
X_779_ _789_/B VGND VGND VPWR VPWR _779_/Y sky130_fd_sc_hd__inv_2
X_495_ _497_/D _495_/B VGND VGND VPWR VPWR _495_/Y sky130_fd_sc_hd__nand2_2
X_564_ _541_/A _564_/B VGND VGND VPWR VPWR _564_/X sky130_fd_sc_hd__and2b_2
X_633_ _663_/C _633_/B VGND VGND VPWR VPWR _633_/Y sky130_fd_sc_hd__xnor2_2
X_702_ _700_/X _702_/B VGND VGND VPWR VPWR _834_/C sky130_fd_sc_hd__nand2b_2
X_478_ _478_/A _492_/B VGND VGND VPWR VPWR _479_/B sky130_fd_sc_hd__nand2_2
X_547_ _501_/B _658_/A _545_/X VGND VGND VPWR VPWR _573_/B sky130_fd_sc_hd__o21ai_2
X_616_ _663_/A _616_/B VGND VGND VPWR VPWR _616_/Y sky130_fd_sc_hd__nand2_2
XFILLER_18_118 VGND VGND VPWR VPWR sky130_fd_sc_hd__decap_3
XFILLER_25_30 VGND VGND VPWR VPWR sky130_fd_sc_hd__fill_1
XFILLER_11_98 VGND VGND VPWR VPWR sky130_fd_sc_hd__decap_3
X_881_ _881_/A _881_/B VGND VGND VPWR VPWR _881_/X sky130_fd_sc_hd__or2_2
XFILLER_20_113 VGND VGND VPWR VPWR sky130_fd_sc_hd__fill_2
Xinput26 A[3] VGND VGND VPWR VPWR _478_/A sky130_fd_sc_hd__clkdlybuf4s25_1
Xinput37 B[13] VGND VGND VPWR VPWR _615_/B sky130_fd_sc_hd__clkdlybuf4s25_1
Xinput48 B[23] VGND VGND VPWR VPWR _771_/B sky130_fd_sc_hd__clkdlybuf4s25_1
Xinput59 B[4] VGND VGND VPWR VPWR _491_/B sky130_fd_sc_hd__clkdlybuf4s25_1
Xinput15 A[22] VGND VGND VPWR VPWR _740_/B sky130_fd_sc_hd__clkdlybuf4s25_1
XFILLER_22_20 VGND VGND VPWR VPWR sky130_fd_sc_hd__fill_1
XFILLER_8_44 VGND VGND VPWR VPWR sky130_fd_sc_hd__fill_1
X_864_ _848_/A _864_/B VGND VGND VPWR VPWR _864_/Y sky130_fd_sc_hd__nand2b_2
X_795_ _795_/A _795_/B _795_/C VGND VGND VPWR VPWR _795_/Y sky130_fd_sc_hd__nand3_2
XFILLER_17_20 VGND VGND VPWR VPWR sky130_fd_sc_hd__fill_1
XFILLER_17_53 VGND VGND VPWR VPWR sky130_fd_sc_hd__decap_3
XFILLER_17_97 VGND VGND VPWR VPWR sky130_fd_sc_hd__decap_3
X_580_ _571_/A _588_/B _724_/B1 VGND VGND VPWR VPWR _580_/Y sky130_fd_sc_hd__o21ai_2
X_847_ _848_/A _864_/B VGND VGND VPWR VPWR _850_/A sky130_fd_sc_hd__nor2_2
X_778_ _834_/A _707_/B _834_/C _834_/D _777_/X VGND VGND VPWR VPWR _789_/B sky130_fd_sc_hd__o41a_2
XFILLER_0_167 VGND VGND VPWR VPWR sky130_fd_sc_hd__fill_1
XPHY_EDGE_ROW_17_Right_17 VGND VGND VPWR VPWR sky130_fd_sc_hd__decap_3
XPHY_EDGE_ROW_26_Right_26 VGND VGND VPWR VPWR sky130_fd_sc_hd__decap_3
X_563_ _563_/A _563_/B VGND VGND VPWR VPWR _575_/B sky130_fd_sc_hd__nor2_2
X_632_ _717_/A _628_/Y _630_/X _626_/X _627_/X VGND VGND VPWR VPWR _633_/B sky130_fd_sc_hd__a32o_2
X_701_ _718_/B _701_/B VGND VGND VPWR VPWR _702_/B sky130_fd_sc_hd__or2_2
X_494_ _497_/D _495_/B VGND VGND VPWR VPWR _494_/X sky130_fd_sc_hd__and2_2
XPHY_EDGE_ROW_17_Left_45 VGND VGND VPWR VPWR sky130_fd_sc_hd__decap_3
X_477_ _478_/A _492_/B VGND VGND VPWR VPWR _487_/B sky130_fd_sc_hd__nor2_2
X_546_ _600_/C _600_/B _551_/A _551_/B VGND VGND VPWR VPWR _658_/A sky130_fd_sc_hd__or4_2
X_615_ _615_/A _615_/B VGND VGND VPWR VPWR _629_/B sky130_fd_sc_hd__xnor2_2
XFILLER_25_53 VGND VGND VPWR VPWR sky130_fd_sc_hd__decap_3
X_529_ _668_/A _518_/Y _551_/A _885_/B2 _528_/Y VGND VGND VPWR VPWR _529_/X sky130_fd_sc_hd__o221a_2
XFILLER_11_77 VGND VGND VPWR VPWR sky130_fd_sc_hd__decap_3
X_880_ _861_/A _863_/X _859_/Y VGND VGND VPWR VPWR _881_/B sky130_fd_sc_hd__a21o_2
Xinput27 A[4] VGND VGND VPWR VPWR _491_/A sky130_fd_sc_hd__clkdlybuf4s25_1
Xinput38 B[14] VGND VGND VPWR VPWR _642_/B sky130_fd_sc_hd__clkdlybuf4s25_1
Xinput49 B[24] VGND VGND VPWR VPWR _791_/B sky130_fd_sc_hd__clkdlybuf4s25_1
Xinput16 A[23] VGND VGND VPWR VPWR _754_/B sky130_fd_sc_hd__clkdlybuf4s25_1
XFILLER_20_136 VGND VGND VPWR VPWR sky130_fd_sc_hd__decap_3
XFILLER_11_158 VGND VGND VPWR VPWR sky130_fd_sc_hd__fill_2
XFILLER_22_98 VGND VGND VPWR VPWR sky130_fd_sc_hd__fill_2
XPHY_EDGE_ROW_5_Left_33 VGND VGND VPWR VPWR sky130_fd_sc_hd__decap_3
X_863_ _843_/A _836_/X _850_/X _862_/X VGND VGND VPWR VPWR _863_/X sky130_fd_sc_hd__o31a_2
X_794_ _793_/B _793_/C _819_/B VGND VGND VPWR VPWR _795_/C sky130_fd_sc_hd__o21ai_2
XFILLER_10_180 VGND VGND VPWR VPWR sky130_fd_sc_hd__fill_2
XFILLER_6_151 VGND VGND VPWR VPWR sky130_fd_sc_hd__fill_1
Xmax_cap102 _625_/Y VGND VGND VPWR VPWR _663_/C sky130_fd_sc_hd__buf_2
X_846_ _886_/A1 _843_/Y _845_/X VGND VGND VPWR VPWR _846_/Y sky130_fd_sc_hd__o21ai_2
X_777_ _715_/Y _834_/D _775_/Y _755_/A VGND VGND VPWR VPWR _777_/X sky130_fd_sc_hd__o211a_2
X_700_ _718_/B _701_/B VGND VGND VPWR VPWR _700_/X sky130_fd_sc_hd__and2_2
X_493_ _497_/D _482_/X _492_/X VGND VGND VPWR VPWR _493_/Y sky130_fd_sc_hd__a21oi_2
X_562_ _541_/A _564_/B _717_/A _561_/X VGND VGND VPWR VPWR _562_/X sky130_fd_sc_hd__a211o_2
X_631_ _598_/A _629_/Y _433_/Y _615_/B VGND VGND VPWR VPWR _631_/X sky130_fd_sc_hd__a2bb2o_2
X_829_ _829_/A _829_/B VGND VGND VPWR VPWR _829_/Y sky130_fd_sc_hd__nand2_2
XFILLER_14_88 VGND VGND VPWR VPWR sky130_fd_sc_hd__decap_3
X_476_ _886_/A1 _473_/Y _475_/X VGND VGND VPWR VPWR _476_/Y sky130_fd_sc_hd__o21ai_2
X_545_ _519_/Y _551_/B _543_/X _544_/X _531_/Y VGND VGND VPWR VPWR _545_/X sky130_fd_sc_hd__o311a_2
X_614_ _615_/A _615_/B VGND VGND VPWR VPWR _614_/Y sky130_fd_sc_hd__nand2_2
XFILLER_25_76 VGND VGND VPWR VPWR sky130_fd_sc_hd__fill_2
XFILLER_2_25 VGND VGND VPWR VPWR sky130_fd_sc_hd__decap_3
X_459_ _468_/A _497_/A _694_/A _458_/Y VGND VGND VPWR VPWR _460_/B sky130_fd_sc_hd__a31o_2
X_528_ _551_/A _526_/X _527_/Y VGND VGND VPWR VPWR _528_/Y sky130_fd_sc_hd__o21ai_2
XFILLER_11_89 VGND VGND VPWR VPWR sky130_fd_sc_hd__decap_3
XFILLER_23_123 VGND VGND VPWR VPWR sky130_fd_sc_hd__fill_1
XFILLER_14_112 VGND VGND VPWR VPWR sky130_fd_sc_hd__fill_1
XFILLER_14_189 VGND VGND VPWR VPWR sky130_fd_sc_hd__fill_1
XTAP_TAPCELL_ROW_16_107 VGND VPWR sky130_fd_sc_hd__tapvpwrvgnd_1
Xinput28 A[5] VGND VGND VPWR VPWR _509_/A sky130_fd_sc_hd__clkdlybuf4s25_1
Xinput39 B[15] VGND VGND VPWR VPWR _639_/B sky130_fd_sc_hd__clkdlybuf4s25_1
Xinput17 A[24] VGND VGND VPWR VPWR _768_/B sky130_fd_sc_hd__clkdlybuf4s25_1
XFILLER_20_104 VGND VGND VPWR VPWR sky130_fd_sc_hd__decap_3
X_862_ _829_/Y _850_/A _855_/B VGND VGND VPWR VPWR _862_/X sky130_fd_sc_hd__o21ba_2
X_793_ _819_/B _793_/B _793_/C VGND VGND VPWR VPWR _795_/B sky130_fd_sc_hd__or3_2
XFILLER_6_141 VGND VGND VPWR VPWR sky130_fd_sc_hd__decap_3
XFILLER_8_68 VGND VGND VPWR VPWR sky130_fd_sc_hd__decap_3
XFILLER_17_44 VGND VGND VPWR VPWR sky130_fd_sc_hd__decap_3
XFILLER_3_188 VGND VGND VPWR VPWR sky130_fd_sc_hd__fill_2
Xmax_cap103 _629_/B VGND VGND VPWR VPWR _663_/B sky130_fd_sc_hd__clkbuf_2
Xmax_cap114 _855_/A VGND VGND VPWR VPWR _751_/A1 sky130_fd_sc_hd__clkbuf_2
X_845_ _870_/A1 _829_/Y _843_/A _871_/A1 _844_/X VGND VGND VPWR VPWR _845_/X sky130_fd_sc_hd__o221a_2
X_776_ _776_/A _776_/B VGND VGND VPWR VPWR _834_/D sky130_fd_sc_hd__or2_2
XPHY_EDGE_ROW_3_Right_3 VGND VGND VPWR VPWR sky130_fd_sc_hd__decap_3
X_492_ _478_/A _492_/B VGND VGND VPWR VPWR _492_/X sky130_fd_sc_hd__and2b_2
X_561_ _541_/A _564_/B _573_/B VGND VGND VPWR VPWR _561_/X sky130_fd_sc_hd__o21a_2
X_630_ _433_/Y _615_/B _629_/Y _598_/A VGND VGND VPWR VPWR _630_/X sky130_fd_sc_hd__o2bb2a_2
X_828_ _829_/A _829_/B VGND VGND VPWR VPWR _831_/B sky130_fd_sc_hd__and2_2
X_759_ _759_/A _759_/B _770_/A VGND VGND VPWR VPWR _776_/B sky130_fd_sc_hd__or3_2
X_613_ _736_/A1 _597_/Y _611_/Y _612_/X VGND VGND VPWR VPWR _613_/Y sky130_fd_sc_hd__o211ai_2
X_475_ _844_/A _465_/Y _498_/B _885_/B2 _474_/X VGND VGND VPWR VPWR _475_/X sky130_fd_sc_hd__o221a_2
X_544_ _544_/A _551_/A _551_/B VGND VGND VPWR VPWR _544_/X sky130_fd_sc_hd__or3_2
XTAP_TAPCELL_ROW_19_116 VGND VPWR sky130_fd_sc_hd__tapvpwrvgnd_1
X_458_ _429_/Y _439_/B _457_/X VGND VGND VPWR VPWR _458_/Y sky130_fd_sc_hd__a21oi_2
X_527_ _551_/A _526_/X _886_/A1 VGND VGND VPWR VPWR _527_/Y sky130_fd_sc_hd__a21oi_2
XFILLER_11_24 VGND VGND VPWR VPWR sky130_fd_sc_hd__fill_1
XFILLER_11_57 VGND VGND VPWR VPWR sky130_fd_sc_hd__decap_3
XTAP_TAPCELL_ROW_16_108 VGND VPWR sky130_fd_sc_hd__tapvpwrvgnd_1
Xinput29 A[6] VGND VGND VPWR VPWR _520_/A sky130_fd_sc_hd__clkdlybuf4s25_1
Xinput18 A[25] VGND VGND VPWR VPWR _787_/B sky130_fd_sc_hd__clkdlybuf4s25_1
XFILLER_11_149 VGND VGND VPWR VPWR sky130_fd_sc_hd__fill_1
XFILLER_22_56 VGND VGND VPWR VPWR sky130_fd_sc_hd__decap_3
XTAP_TAPCELL_ROW_21_122 VGND VPWR sky130_fd_sc_hd__tapvpwrvgnd_1
X_861_ _861_/A _861_/B VGND VGND VPWR VPWR _868_/A sky130_fd_sc_hd__nand2_2
X_792_ _819_/A _774_/X _791_/X _790_/A VGND VGND VPWR VPWR _793_/C sky130_fd_sc_hd__a211oi_2
XFILLER_6_186 VGND VGND VPWR VPWR sky130_fd_sc_hd__decap_3
X_844_ _844_/A _844_/B VGND VGND VPWR VPWR _844_/X sky130_fd_sc_hd__or2_2
X_775_ _775_/A _775_/B VGND VGND VPWR VPWR _775_/Y sky130_fd_sc_hd__nand2_2
Xmax_cap104 _571_/Y VGND VGND VPWR VPWR _607_/A sky130_fd_sc_hd__buf_2
X_491_ _491_/A _491_/B VGND VGND VPWR VPWR _510_/A sky130_fd_sc_hd__xnor2_2
X_560_ _560_/A _576_/B VGND VGND VPWR VPWR _566_/A sky130_fd_sc_hd__xnor2_2
XPHY_EDGE_ROW_13_Right_13 VGND VGND VPWR VPWR sky130_fd_sc_hd__decap_3
XPHY_EDGE_ROW_22_Right_22 VGND VGND VPWR VPWR sky130_fd_sc_hd__decap_3
X_827_ _829_/A _829_/B VGND VGND VPWR VPWR _844_/B sky130_fd_sc_hd__nor2_2
X_758_ _721_/X _770_/A _770_/B _757_/X _821_/C1 VGND VGND VPWR VPWR _758_/X sky130_fd_sc_hd__a311o_2
X_689_ _671_/X _686_/X _842_/S VGND VGND VPWR VPWR _689_/Y sky130_fd_sc_hd__a21oi_2
X_474_ _668_/A _474_/B VGND VGND VPWR VPWR _474_/X sky130_fd_sc_hd__or2_2
X_543_ _490_/Y _600_/B _518_/Y VGND VGND VPWR VPWR _543_/X sky130_fd_sc_hd__o21a_2
X_612_ _795_/A _610_/X _663_/A _710_/A VGND VGND VPWR VPWR _612_/X sky130_fd_sc_hd__o2bb2a_2
XFILLER_17_100 VGND VGND VPWR VPWR sky130_fd_sc_hd__fill_2
XTAP_TAPCELL_ROW_19_117 VGND VPWR sky130_fd_sc_hd__tapvpwrvgnd_1
X_526_ _842_/S _525_/X _534_/B VGND VGND VPWR VPWR _526_/X sky130_fd_sc_hd__o21ba_2
XFILLER_23_169 VGND VGND VPWR VPWR sky130_fd_sc_hd__fill_1
X_457_ _483_/A _483_/B _694_/A VGND VGND VPWR VPWR _457_/X sky130_fd_sc_hd__a21o_2
XTAP_TAPCELL_ROW_16_109 VGND VPWR sky130_fd_sc_hd__tapvpwrvgnd_1
XTAP_TAPCELL_ROW_24_131 VGND VPWR sky130_fd_sc_hd__tapvpwrvgnd_1
Xinput19 A[26] VGND VGND VPWR VPWR _799_/B sky130_fd_sc_hd__clkdlybuf4s25_1
XFILLER_20_139 VGND VGND VPWR VPWR sky130_fd_sc_hd__fill_1
X_509_ _509_/A _521_/B VGND VGND VPWR VPWR _600_/B sky130_fd_sc_hd__xnor2_2
XFILLER_11_117 VGND VGND VPWR VPWR sky130_fd_sc_hd__decap_3
XFILLER_22_68 VGND VGND VPWR VPWR sky130_fd_sc_hd__decap_3
XTAP_TAPCELL_ROW_21_123 VGND VPWR sky130_fd_sc_hd__tapvpwrvgnd_1
Xfanout130 _888_/C VGND VGND VPWR VPWR _451_/C sky130_fd_sc_hd__clkdlybuf4s25_1
X_860_ _877_/B _878_/B VGND VGND VPWR VPWR _861_/B sky130_fd_sc_hd__or2_2
X_791_ _768_/B _791_/B VGND VGND VPWR VPWR _791_/X sky130_fd_sc_hd__and2b_2
XFILLER_17_57 VGND VGND VPWR VPWR sky130_fd_sc_hd__decap_3
XFILLER_3_102 VGND VGND VPWR VPWR sky130_fd_sc_hd__decap_3
XPHY_EDGE_ROW_9_Left_37 VGND VGND VPWR VPWR sky130_fd_sc_hd__decap_3
X_843_ _843_/A _843_/B VGND VGND VPWR VPWR _843_/Y sky130_fd_sc_hd__xnor2_2
X_774_ _691_/A _838_/A _772_/X VGND VGND VPWR VPWR _774_/X sky130_fd_sc_hd__a21o_2
Xmax_cap105 _566_/A VGND VGND VPWR VPWR _599_/B sky130_fd_sc_hd__clkbuf_2
XFILLER_0_149 VGND VGND VPWR VPWR sky130_fd_sc_hd__fill_1
XFILLER_9_91 VGND VGND VPWR VPWR sky130_fd_sc_hd__decap_3
X_490_ _491_/A _491_/B VGND VGND VPWR VPWR _490_/Y sky130_fd_sc_hd__nand2_2
X_826_ _826_/A _826_/B _825_/X VGND VGND VPWR VPWR _826_/X sky130_fd_sc_hd__or3b_2
X_757_ _770_/A _743_/X _756_/X VGND VGND VPWR VPWR _757_/X sky130_fd_sc_hd__a21o_2
X_688_ _662_/A _662_/B _834_/B VGND VGND VPWR VPWR _707_/B sky130_fd_sc_hd__a21o_2
X_473_ _498_/B _473_/B VGND VGND VPWR VPWR _473_/Y sky130_fd_sc_hd__xnor2_2
X_542_ _599_/A VGND VGND VPWR VPWR _563_/A sky130_fd_sc_hd__inv_2
X_611_ _598_/A _629_/A _724_/B1 VGND VGND VPWR VPWR _611_/Y sky130_fd_sc_hd__o21ai_2
XFILLER_6_92 VGND VGND VPWR VPWR sky130_fd_sc_hd__fill_1
X_809_ _844_/A _798_/Y _800_/B _870_/A1 VGND VGND VPWR VPWR _809_/X sky130_fd_sc_hd__o22a_2
XFILLER_25_57 VGND VGND VPWR VPWR sky130_fd_sc_hd__decap_3
XTAP_TAPCELL_ROW_19_118 VGND VPWR sky130_fd_sc_hd__tapvpwrvgnd_1
XFILLER_17_178 VGND VGND VPWR VPWR sky130_fd_sc_hd__decap_3
XFILLER_23_104 VGND VGND VPWR VPWR sky130_fd_sc_hd__fill_1
XTAP_TAPCELL_ROW_27_140 VGND VPWR sky130_fd_sc_hd__tapvpwrvgnd_1
X_456_ _456_/A _469_/B VGND VGND VPWR VPWR _456_/Y sky130_fd_sc_hd__xnor2_2
X_525_ _508_/Y _512_/X _544_/A VGND VGND VPWR VPWR _525_/X sky130_fd_sc_hd__o21a_2
XTAP_TAPCELL_ROW_24_132 VGND VPWR sky130_fd_sc_hd__tapvpwrvgnd_1
XFILLER_20_107 VGND VGND VPWR VPWR sky130_fd_sc_hd__decap_3
X_439_ _439_/A _439_/B VGND VGND VPWR VPWR _483_/B sky130_fd_sc_hd__xnor2_2
X_508_ _509_/A _521_/B VGND VGND VPWR VPWR _508_/Y sky130_fd_sc_hd__nor2_2
XFILLER_22_36 VGND VGND VPWR VPWR sky130_fd_sc_hd__decap_3
XFILLER_3_82 VGND VGND VPWR VPWR sky130_fd_sc_hd__fill_2
XFILLER_3_93 VGND VGND VPWR VPWR sky130_fd_sc_hd__fill_2
XTAP_TAPCELL_ROW_21_124 VGND VPWR sky130_fd_sc_hd__tapvpwrvgnd_1
Xfanout120 _443_/X VGND VGND VPWR VPWR _766_/A1 sky130_fd_sc_hd__clkdlybuf4s25_1
X_790_ _790_/A _790_/B _790_/C VGND VGND VPWR VPWR _793_/B sky130_fd_sc_hd__and3_2
XPHY_EDGE_ROW_25_Left_53 VGND VGND VPWR VPWR sky130_fd_sc_hd__decap_3
X_842_ _836_/X _841_/Y _842_/S VGND VGND VPWR VPWR _843_/B sky130_fd_sc_hd__mux2_1
Xmax_cap106 _510_/A VGND VGND VPWR VPWR _600_/C sky130_fd_sc_hd__buf_2
X_773_ _773_/A _773_/B VGND VGND VPWR VPWR _838_/A sky130_fd_sc_hd__and2_2
XFILLER_0_139 VGND VGND VPWR VPWR sky130_fd_sc_hd__fill_1
X_825_ _870_/A1 _814_/A _812_/Y _844_/A VGND VGND VPWR VPWR _825_/X sky130_fd_sc_hd__o22a_2
X_756_ _740_/B _756_/B VGND VGND VPWR VPWR _756_/X sky130_fd_sc_hd__and2b_2
X_687_ _690_/A _690_/B VGND VGND VPWR VPWR _834_/B sky130_fd_sc_hd__nand2_2
XPHY_EDGE_ROW_12_Left_40 VGND VGND VPWR VPWR sky130_fd_sc_hd__decap_3
XPHY_EDGE_ROW_7_Right_7 VGND VGND VPWR VPWR sky130_fd_sc_hd__decap_3
X_472_ _694_/A _467_/X _468_/X _471_/Y VGND VGND VPWR VPWR _473_/B sky130_fd_sc_hd__a31o_2
X_541_ _541_/A _564_/B VGND VGND VPWR VPWR _599_/A sky130_fd_sc_hd__xnor2_2
X_610_ _663_/A _610_/B VGND VGND VPWR VPWR _610_/X sky130_fd_sc_hd__xor2_2
XFILLER_20_80 VGND VGND VPWR VPWR sky130_fd_sc_hd__decap_3
X_808_ _808_/A _808_/B _808_/C VGND VGND VPWR VPWR _808_/Y sky130_fd_sc_hd__nand3_2
X_739_ _756_/B _740_/B VGND VGND VPWR VPWR _739_/X sky130_fd_sc_hd__or2_2
XFILLER_26_157 VGND VGND VPWR VPWR sky130_fd_sc_hd__decap_3
XFILLER_26_168 VGND VGND VPWR VPWR sky130_fd_sc_hd__fill_1
XFILLER_17_113 VGND VGND VPWR VPWR sky130_fd_sc_hd__decap_3
XFILLER_17_135 VGND VGND VPWR VPWR sky130_fd_sc_hd__decap_3
XFILLER_2_29 VGND VGND VPWR VPWR sky130_fd_sc_hd__fill_1
XTAP_TAPCELL_ROW_27_141 VGND VPWR sky130_fd_sc_hd__tapvpwrvgnd_1
X_455_ _456_/A _469_/B VGND VGND VPWR VPWR _498_/A sky130_fd_sc_hd__nand2_2
X_524_ _717_/A _524_/B VGND VGND VPWR VPWR _534_/B sky130_fd_sc_hd__and2_2
Xoutput90 _846_/Y VGND VGND VPWR VPWR y[28] sky130_fd_sc_hd__clkdlybuf4s25_1
XFILLER_14_105 VGND VGND VPWR VPWR sky130_fd_sc_hd__fill_1
XTAP_TAPCELL_ROW_24_133 VGND VPWR sky130_fd_sc_hd__tapvpwrvgnd_1
XFILLER_11_108 VGND VGND VPWR VPWR sky130_fd_sc_hd__decap_3
XFILLER_9_164 VGND VGND VPWR VPWR sky130_fd_sc_hd__decap_3
X_438_ _439_/A _439_/B VGND VGND VPWR VPWR _440_/B sky130_fd_sc_hd__xor2_2
X_507_ _509_/A _521_/B VGND VGND VPWR VPWR _544_/A sky130_fd_sc_hd__nand2_2
XFILLER_10_141 VGND VGND VPWR VPWR sky130_fd_sc_hd__fill_2
Xfanout121 _443_/X VGND VGND VPWR VPWR _886_/A1 sky130_fd_sc_hd__clkdlybuf4s25_1
Xfanout110 _884_/A VGND VGND VPWR VPWR _782_/A sky130_fd_sc_hd__clkdlybuf4s25_1
XFILLER_6_189 VGND VGND VPWR VPWR sky130_fd_sc_hd__fill_1
XFILLER_3_126 VGND VGND VPWR VPWR sky130_fd_sc_hd__fill_1
Xmax_cap107 _456_/Y VGND VGND VPWR VPWR _497_/B sky130_fd_sc_hd__buf_2
X_841_ _691_/A _838_/X _840_/X VGND VGND VPWR VPWR _841_/Y sky130_fd_sc_hd__a21oi_2
X_772_ _776_/A _757_/X _773_/B _719_/X _771_/X VGND VGND VPWR VPWR _772_/X sky130_fd_sc_hd__a221o_2
XFILLER_17_3 VGND VGND VPWR VPWR sky130_fd_sc_hd__fill_1
XFILLER_18_80 VGND VGND VPWR VPWR sky130_fd_sc_hd__decap_3
X_824_ _824_/A _838_/B VGND VGND VPWR VPWR _826_/B sky130_fd_sc_hd__nor2_2
X_755_ _755_/A _775_/A VGND VGND VPWR VPWR _776_/A sky130_fd_sc_hd__nand2_2
X_686_ _676_/B _654_/B _692_/B _672_/B VGND VGND VPWR VPWR _686_/X sky130_fd_sc_hd__a22o_2
X_471_ _483_/A _483_/B _497_/B _470_/X _694_/A VGND VGND VPWR VPWR _471_/Y sky130_fd_sc_hd__a311oi_2
X_540_ _541_/A _564_/B VGND VGND VPWR VPWR _540_/Y sky130_fd_sc_hd__nand2_2
X_807_ _806_/B _806_/C _819_/C VGND VGND VPWR VPWR _808_/C sky130_fd_sc_hd__o21ai_2
X_738_ _756_/B _740_/B VGND VGND VPWR VPWR _738_/X sky130_fd_sc_hd__and2_2
X_669_ _782_/A _655_/A _690_/A _446_/Y _668_/Y VGND VGND VPWR VPWR _669_/X sky130_fd_sc_hd__a221o_2
XTAP_TAPCELL_ROW_27_142 VGND VPWR sky130_fd_sc_hd__tapvpwrvgnd_1
X_454_ _497_/A _445_/X _453_/X VGND VGND VPWR VPWR _454_/X sky130_fd_sc_hd__a21bo_2
X_523_ _600_/C _510_/B _600_/B _522_/X VGND VGND VPWR VPWR _524_/B sky130_fd_sc_hd__a31o_2
Xoutput80 _712_/X VGND VGND VPWR VPWR y[19] sky130_fd_sc_hd__clkdlybuf4s25_1
Xoutput91 _857_/X VGND VGND VPWR VPWR y[29] sky130_fd_sc_hd__clkdlybuf4s25_1
XFILLER_9_110 VGND VGND VPWR VPWR sky130_fd_sc_hd__fill_2
X_437_ _439_/A _439_/B VGND VGND VPWR VPWR _468_/A sky130_fd_sc_hd__nand2_2
X_506_ _886_/A1 _503_/Y _505_/X VGND VGND VPWR VPWR _506_/Y sky130_fd_sc_hd__o21ai_2
Xfanout122 _442_/X VGND VGND VPWR VPWR _609_/S sky130_fd_sc_hd__clkdlybuf4s25_1
Xfanout111 _870_/A1 VGND VGND VPWR VPWR _736_/A1 sky130_fd_sc_hd__clkdlybuf4s25_1
XFILLER_12_82 VGND VGND VPWR VPWR sky130_fd_sc_hd__fill_2
XFILLER_8_29 VGND VGND VPWR VPWR sky130_fd_sc_hd__fill_2
XTAP_TAPCELL_ROW_8_83 VGND VPWR sky130_fd_sc_hd__tapvpwrvgnd_1
XFILLER_23_81 VGND VGND VPWR VPWR sky130_fd_sc_hd__decap_3
X_840_ _838_/B _839_/X _837_/X VGND VGND VPWR VPWR _840_/X sky130_fd_sc_hd__a21o_2
X_771_ _754_/B _771_/B VGND VGND VPWR VPWR _771_/X sky130_fd_sc_hd__and2b_2
XFILLER_9_94 VGND VGND VPWR VPWR sky130_fd_sc_hd__decap_3
X_823_ _838_/B _818_/Y _821_/X _822_/Y _795_/A VGND VGND VPWR VPWR _826_/A sky130_fd_sc_hd__o311a_2
XFILLER_18_70 VGND VGND VPWR VPWR sky130_fd_sc_hd__fill_2
X_754_ _771_/B _754_/B VGND VGND VPWR VPWR _775_/A sky130_fd_sc_hd__or2_2
X_685_ _697_/B _685_/B VGND VGND VPWR VPWR _834_/A sky130_fd_sc_hd__or2_2
X_470_ _429_/Y _439_/B _456_/Y _469_/X VGND VGND VPWR VPWR _470_/X sky130_fd_sc_hd__a31o_2
X_599_ _599_/A _599_/B _607_/A _607_/B VGND VGND VPWR VPWR _599_/Y sky130_fd_sc_hd__nand4_2
X_806_ _819_/C _806_/B _806_/C VGND VGND VPWR VPWR _808_/B sky130_fd_sc_hd__or3_2
X_737_ _766_/A1 _734_/Y _736_/X VGND VGND VPWR VPWR _737_/Y sky130_fd_sc_hd__o21ai_2
X_668_ _668_/A _674_/A VGND VGND VPWR VPWR _668_/Y sky130_fd_sc_hd__nor2_2
XFILLER_25_27 VGND VGND VPWR VPWR sky130_fd_sc_hd__decap_3
XFILLER_15_82 VGND VGND VPWR VPWR sky130_fd_sc_hd__decap_3
XTAP_TAPCELL_ROW_27_143 VGND VPWR sky130_fd_sc_hd__tapvpwrvgnd_1
X_453_ _483_/B _885_/B2 _668_/A _468_/A _452_/Y VGND VGND VPWR VPWR _453_/X sky130_fd_sc_hd__o221a_2
X_522_ _430_/Y _491_/B _600_/B _521_/X VGND VGND VPWR VPWR _522_/X sky130_fd_sc_hd__a31o_2
Xoutput70 _454_/X VGND VGND VPWR VPWR y[0] sky130_fd_sc_hd__clkdlybuf4s25_1
Xoutput81 _463_/Y VGND VGND VPWR VPWR y[1] sky130_fd_sc_hd__clkdlybuf4s25_1
Xoutput92 _476_/Y VGND VGND VPWR VPWR y[2] sky130_fd_sc_hd__clkdlybuf4s25_1
XFILLER_7_3 VGND VGND VPWR VPWR sky130_fd_sc_hd__fill_1
X_436_ _874_/B VGND VGND VPWR VPWR _436_/Y sky130_fd_sc_hd__inv_2
X_505_ _668_/A _490_/Y _600_/C _885_/B2 _504_/Y VGND VGND VPWR VPWR _505_/X sky130_fd_sc_hd__o221a_2
XFILLER_22_39 VGND VGND VPWR VPWR sky130_fd_sc_hd__decap_3
Xfanout123 _442_/X VGND VGND VPWR VPWR _821_/C1 sky130_fd_sc_hd__clkdlybuf4s25_1
Xfanout112 _870_/A1 VGND VGND VPWR VPWR _668_/A sky130_fd_sc_hd__clkdlybuf4s25_1
XFILLER_17_17 VGND VGND VPWR VPWR sky130_fd_sc_hd__decap_3
XTAP_TAPCELL_ROW_8_84 VGND VPWR sky130_fd_sc_hd__tapvpwrvgnd_1
X_770_ _770_/A _770_/B _776_/A VGND VGND VPWR VPWR _773_/B sky130_fd_sc_hd__and3_2
XFILLER_9_62 VGND VGND VPWR VPWR sky130_fd_sc_hd__decap_3
XTAP_TAPCELL_ROW_5_74 VGND VPWR sky130_fd_sc_hd__tapvpwrvgnd_1
X_822_ _818_/Y _821_/X _838_/B VGND VGND VPWR VPWR _822_/Y sky130_fd_sc_hd__o21ai_2
X_753_ _771_/B _754_/B VGND VGND VPWR VPWR _755_/A sky130_fd_sc_hd__nand2_2
X_684_ _703_/B _684_/B VGND VGND VPWR VPWR _684_/X sky130_fd_sc_hd__or2_2
XFILLER_14_29 VGND VGND VPWR VPWR sky130_fd_sc_hd__fill_1
XFILLER_22_3 VGND VGND VPWR VPWR sky130_fd_sc_hd__fill_1
XFILLER_20_83 VGND VGND VPWR VPWR sky130_fd_sc_hd__fill_1
X_805_ _819_/B _790_/C _804_/X _790_/A VGND VGND VPWR VPWR _806_/C sky130_fd_sc_hd__o211a_2
X_736_ _736_/A1 _727_/Y _759_/B _824_/A _735_/Y VGND VGND VPWR VPWR _736_/X sky130_fd_sc_hd__o221a_2
XPHY_EDGE_ROW_16_Left_44 VGND VGND VPWR VPWR sky130_fd_sc_hd__decap_3
X_598_ _598_/A _629_/A VGND VGND VPWR VPWR _663_/A sky130_fd_sc_hd__xnor2_2
X_667_ _690_/A _667_/B VGND VGND VPWR VPWR _667_/X sky130_fd_sc_hd__xor2_2
XFILLER_17_138 VGND VGND VPWR VPWR sky130_fd_sc_hd__fill_1
XTAP_TAPCELL_ROW_27_144 VGND VPWR sky130_fd_sc_hd__tapvpwrvgnd_1
X_452_ _439_/A _439_/B _782_/A VGND VGND VPWR VPWR _452_/Y sky130_fd_sc_hd__o21ai_2
X_521_ _509_/A _521_/B VGND VGND VPWR VPWR _521_/X sky130_fd_sc_hd__and2b_2
Xoutput71 _582_/Y VGND VGND VPWR VPWR y[10] sky130_fd_sc_hd__clkdlybuf4s25_1
Xoutput82 _726_/Y VGND VGND VPWR VPWR y[20] sky130_fd_sc_hd__clkdlybuf4s25_1
Xoutput93 _872_/X VGND VGND VPWR VPWR y[30] sky130_fd_sc_hd__clkdlybuf4s25_1
X_719_ _834_/C _704_/X _718_/X VGND VGND VPWR VPWR _719_/X sky130_fd_sc_hd__a21o_2
XPHY_EDGE_ROW_1_Left_29 VGND VGND VPWR VPWR sky130_fd_sc_hd__decap_3
XFILLER_13_130 VGND VGND VPWR VPWR sky130_fd_sc_hd__fill_1
XFILLER_9_167 VGND VGND VPWR VPWR sky130_fd_sc_hd__fill_1
X_435_ _829_/B VGND VGND VPWR VPWR _435_/Y sky130_fd_sc_hd__inv_2
X_504_ _491_/A _491_/B _782_/A VGND VGND VPWR VPWR _504_/Y sky130_fd_sc_hd__o21ai_2
Xfanout113 _449_/X VGND VGND VPWR VPWR _870_/A1 sky130_fd_sc_hd__clkdlybuf4s25_1
XFILLER_10_100 VGND VGND VPWR VPWR sky130_fd_sc_hd__decap_3
XTAP_TAPCELL_ROW_12_95 VGND VPWR sky130_fd_sc_hd__tapvpwrvgnd_1
Xfanout124 _442_/X VGND VGND VPWR VPWR _694_/A sky130_fd_sc_hd__clkdlybuf4s25_1
XTAP_TAPCELL_ROW_8_85 VGND VPWR sky130_fd_sc_hd__tapvpwrvgnd_1
XFILLER_3_118 VGND VGND VPWR VPWR sky130_fd_sc_hd__fill_1
XFILLER_23_72 VGND VGND VPWR VPWR sky130_fd_sc_hd__fill_1
XPHY_EDGE_ROW_4_Left_32 VGND VGND VPWR VPWR sky130_fd_sc_hd__decap_3
XFILLER_18_83 VGND VGND VPWR VPWR sky130_fd_sc_hd__fill_1
XTAP_TAPCELL_ROW_5_75 VGND VPWR sky130_fd_sc_hd__tapvpwrvgnd_1
X_821_ _789_/B _832_/B _820_/X _821_/C1 VGND VGND VPWR VPWR _821_/X sky130_fd_sc_hd__o211a_2
X_752_ _795_/A _749_/Y _751_/X VGND VGND VPWR VPWR _752_/X sky130_fd_sc_hd__a21o_2
X_683_ _703_/B _684_/B VGND VGND VPWR VPWR _685_/B sky130_fd_sc_hd__nor2_2
XFILLER_15_3 VGND VGND VPWR VPWR sky130_fd_sc_hd__decap_3
X_597_ _598_/A _629_/A VGND VGND VPWR VPWR _597_/Y sky130_fd_sc_hd__nand2_2
X_804_ _790_/B _786_/Y _788_/A VGND VGND VPWR VPWR _804_/X sky130_fd_sc_hd__o21a_2
X_735_ _782_/A _746_/A VGND VGND VPWR VPWR _735_/Y sky130_fd_sc_hd__nand2_2
X_666_ _662_/Y _691_/A _717_/A VGND VGND VPWR VPWR _667_/B sky130_fd_sc_hd__mux2_1
X_520_ _520_/A _520_/B VGND VGND VPWR VPWR _551_/A sky130_fd_sc_hd__xnor2_2
XTAP_TAPCELL_ROW_27_145 VGND VPWR sky130_fd_sc_hd__tapvpwrvgnd_1
XTAP_TAPCELL_ROW_2_65 VGND VPWR sky130_fd_sc_hd__tapvpwrvgnd_1
X_451_ _449_/A _888_/B _451_/C VGND VGND VPWR VPWR _451_/Y sky130_fd_sc_hd__nand3b_2
Xoutput72 _596_/Y VGND VGND VPWR VPWR y[11] sky130_fd_sc_hd__clkdlybuf4s25_1
Xoutput83 _737_/Y VGND VGND VPWR VPWR y[21] sky130_fd_sc_hd__clkdlybuf4s25_1
Xoutput94 _886_/Y VGND VGND VPWR VPWR y[31] sky130_fd_sc_hd__clkdlybuf4s25_1
X_718_ _701_/B _718_/B VGND VGND VPWR VPWR _718_/X sky130_fd_sc_hd__and2b_2
X_649_ _664_/A _649_/B VGND VGND VPWR VPWR _649_/Y sky130_fd_sc_hd__xnor2_2
XFILLER_22_120 VGND VGND VPWR VPWR sky130_fd_sc_hd__decap_3
XTAP_TAPCELL_ROW_15_104 VGND VPWR sky130_fd_sc_hd__tapvpwrvgnd_1
X_434_ _639_/A VGND VGND VPWR VPWR _434_/Y sky130_fd_sc_hd__inv_2
X_503_ _600_/C _503_/B VGND VGND VPWR VPWR _503_/Y sky130_fd_sc_hd__xnor2_2
XFILLER_3_65 VGND VGND VPWR VPWR sky130_fd_sc_hd__decap_3
XFILLER_10_112 VGND VGND VPWR VPWR sky130_fd_sc_hd__fill_1
XTAP_TAPCELL_ROW_12_96 VGND VPWR sky130_fd_sc_hd__tapvpwrvgnd_1
Xfanout125 _442_/X VGND VGND VPWR VPWR _790_/A sky130_fd_sc_hd__clkdlybuf4s25_1
XPHY_EDGE_ROW_16_Right_16 VGND VGND VPWR VPWR sky130_fd_sc_hd__decap_3
XPHY_EDGE_ROW_25_Right_25 VGND VGND VPWR VPWR sky130_fd_sc_hd__decap_3
XFILLER_23_51 VGND VGND VPWR VPWR sky130_fd_sc_hd__decap_3
XFILLER_23_84 VGND VGND VPWR VPWR sky130_fd_sc_hd__decap_3
XFILLER_9_53 VGND VGND VPWR VPWR sky130_fd_sc_hd__decap_3
XFILLER_9_97 VGND VGND VPWR VPWR sky130_fd_sc_hd__fill_2
XFILLER_18_40 VGND VGND VPWR VPWR sky130_fd_sc_hd__decap_3
X_820_ _800_/B _804_/X _798_/Y VGND VGND VPWR VPWR _820_/X sky130_fd_sc_hd__a21o_2
X_751_ _751_/A1 _738_/X _739_/X _782_/A _750_/Y VGND VGND VPWR VPWR _751_/X sky130_fd_sc_hd__a221o_2
X_682_ _703_/B _684_/B VGND VGND VPWR VPWR _697_/B sky130_fd_sc_hd__and2_2
XTAP_TAPCELL_ROW_5_76 VGND VPWR sky130_fd_sc_hd__tapvpwrvgnd_1
XPHY_EDGE_ROW_2_Right_2 VGND VGND VPWR VPWR sky130_fd_sc_hd__decap_3
XFILLER_20_41 VGND VGND VPWR VPWR sky130_fd_sc_hd__fill_2
XFILLER_20_52 VGND VGND VPWR VPWR sky130_fd_sc_hd__decap_3
XFILLER_20_85 VGND VGND VPWR VPWR sky130_fd_sc_hd__decap_3
XFILLER_6_32 VGND VGND VPWR VPWR sky130_fd_sc_hd__fill_1
X_596_ _766_/A1 _593_/Y _595_/X VGND VGND VPWR VPWR _596_/Y sky130_fd_sc_hd__o21ai_2
X_803_ _819_/A _774_/X _819_/B _802_/X _790_/A VGND VGND VPWR VPWR _806_/B sky130_fd_sc_hd__a311oi_2
X_734_ _759_/B _734_/B VGND VGND VPWR VPWR _734_/Y sky130_fd_sc_hd__xnor2_2
X_665_ _434_/Y _639_/B _616_/B _663_/X _664_/Y VGND VGND VPWR VPWR _691_/A sky130_fd_sc_hd__a221o_2
XFILLER_19_181 VGND VGND VPWR VPWR sky130_fd_sc_hd__fill_1
XFILLER_25_19 VGND VGND VPWR VPWR sky130_fd_sc_hd__fill_1
XTAP_TAPCELL_ROW_2_66 VGND VPWR sky130_fd_sc_hd__tapvpwrvgnd_1
X_450_ _449_/A _888_/B _451_/C VGND VGND VPWR VPWR _884_/A sky130_fd_sc_hd__and3b_2
Xoutput73 _613_/Y VGND VGND VPWR VPWR y[12] sky130_fd_sc_hd__clkdlybuf4s25_1
Xoutput84 _752_/X VGND VGND VPWR VPWR y[22] sky130_fd_sc_hd__clkdlybuf4s25_1
Xoutput95 _489_/Y VGND VGND VPWR VPWR y[3] sky130_fd_sc_hd__clkdlybuf4s25_1
XFILLER_16_162 VGND VGND VPWR VPWR sky130_fd_sc_hd__decap_3
XTAP_TAPCELL_ROW_18_113 VGND VPWR sky130_fd_sc_hd__tapvpwrvgnd_1
X_579_ _607_/A _579_/B VGND VGND VPWR VPWR _579_/X sky130_fd_sc_hd__xor2_2
X_717_ _717_/A _760_/A VGND VGND VPWR VPWR _717_/Y sky130_fd_sc_hd__nor2_2
X_648_ _717_/A _641_/Y _664_/B _647_/X VGND VGND VPWR VPWR _649_/B sky130_fd_sc_hd__a31o_2
XTAP_TAPCELL_ROW_15_105 VGND VPWR sky130_fd_sc_hd__tapvpwrvgnd_1
X_433_ _615_/A VGND VGND VPWR VPWR _433_/Y sky130_fd_sc_hd__inv_2
X_502_ _609_/S _510_/B _501_/Y VGND VGND VPWR VPWR _503_/B sky130_fd_sc_hd__o21ai_2
XFILLER_3_33 VGND VGND VPWR VPWR sky130_fd_sc_hd__decap_3
XFILLER_10_168 VGND VGND VPWR VPWR sky130_fd_sc_hd__decap_3
XTAP_TAPCELL_ROW_12_97 VGND VPWR sky130_fd_sc_hd__tapvpwrvgnd_1
Xfanout126 _762_/A1 VGND VGND VPWR VPWR _717_/A sky130_fd_sc_hd__clkdlybuf4s25_1
Xfanout115 _447_/X VGND VGND VPWR VPWR _710_/A sky130_fd_sc_hd__clkdlybuf4s25_1
XFILLER_5_3 VGND VGND VPWR VPWR sky130_fd_sc_hd__fill_2
XFILLER_9_65 VGND VGND VPWR VPWR sky130_fd_sc_hd__decap_3
XFILLER_18_85 VGND VGND VPWR VPWR sky130_fd_sc_hd__decap_3
X_750_ _824_/A _770_/A VGND VGND VPWR VPWR _750_/Y sky130_fd_sc_hd__nor2_2
X_681_ _795_/A _678_/Y _680_/X VGND VGND VPWR VPWR _681_/X sky130_fd_sc_hd__a21o_2
X_879_ _830_/Y _841_/Y _849_/Y _865_/X _878_/Y VGND VGND VPWR VPWR _879_/X sky130_fd_sc_hd__o311a_2
X_595_ _736_/A1 _584_/Y _594_/X VGND VGND VPWR VPWR _595_/X sky130_fd_sc_hd__o21a_2
X_802_ _819_/B _791_/X _801_/X VGND VGND VPWR VPWR _802_/X sky130_fd_sc_hd__a21o_2
X_733_ _762_/A1 _732_/Y _730_/X VGND VGND VPWR VPWR _734_/B sky130_fd_sc_hd__a21o_2
X_664_ _664_/A _664_/B VGND VGND VPWR VPWR _664_/Y sky130_fd_sc_hd__nor2_2
XTAP_TAPCELL_ROW_2_67 VGND VPWR sky130_fd_sc_hd__tapvpwrvgnd_1
XTAP_TAPCELL_ROW_18_114 VGND VPWR sky130_fd_sc_hd__tapvpwrvgnd_1
X_578_ _609_/S _575_/X _577_/X _574_/Y VGND VGND VPWR VPWR _579_/B sky130_fd_sc_hd__o31a_2
Xoutput74 _623_/Y VGND VGND VPWR VPWR y[13] sky130_fd_sc_hd__clkdlybuf4s25_1
Xoutput85 _766_/Y VGND VGND VPWR VPWR y[23] sky130_fd_sc_hd__clkdlybuf4s25_1
Xoutput96 _506_/Y VGND VGND VPWR VPWR y[4] sky130_fd_sc_hd__clkdlybuf4s25_1
X_716_ _834_/A _707_/B _834_/C _715_/Y VGND VGND VPWR VPWR _760_/A sky130_fd_sc_hd__o31a_2
X_647_ _663_/C _626_/X _646_/Y _821_/C1 VGND VGND VPWR VPWR _647_/X sky130_fd_sc_hd__o211a_2
.ends
