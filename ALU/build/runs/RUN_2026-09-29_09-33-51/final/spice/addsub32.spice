* NGSPICE file created from addsub32.ext - technology: sky130A

* Black-box entry subcircuit for sky130_fd_sc_hd__decap_3 abstract view
.subckt sky130_fd_sc_hd__decap_3 VGND VNB VPB VPWR
.ends

* Black-box entry subcircuit for sky130_fd_sc_hd__fill_1 abstract view
.subckt sky130_fd_sc_hd__fill_1 VGND VNB VPB VPWR
.ends

* Black-box entry subcircuit for sky130_fd_sc_hd__xnor2_2 abstract view
.subckt sky130_fd_sc_hd__xnor2_2 A B VGND VNB VPB VPWR Y
.ends

* Black-box entry subcircuit for sky130_fd_sc_hd__xnor2_4 abstract view
.subckt sky130_fd_sc_hd__xnor2_4 A B VGND VNB VPB VPWR Y
.ends

* Black-box entry subcircuit for sky130_fd_sc_hd__fill_2 abstract view
.subckt sky130_fd_sc_hd__fill_2 VGND VNB VPB VPWR
.ends

* Black-box entry subcircuit for sky130_fd_sc_hd__nand4_2 abstract view
.subckt sky130_fd_sc_hd__nand4_2 A B C D VGND VNB VPB VPWR Y
.ends

* Black-box entry subcircuit for sky130_fd_sc_hd__buf_8 abstract view
.subckt sky130_fd_sc_hd__buf_8 A VGND VNB VPB VPWR X
.ends

* Black-box entry subcircuit for sky130_fd_sc_hd__buf_6 abstract view
.subckt sky130_fd_sc_hd__buf_6 A VGND VNB VPB VPWR X
.ends

* Black-box entry subcircuit for sky130_fd_sc_hd__a221o_2 abstract view
.subckt sky130_fd_sc_hd__a221o_2 A1 A2 B1 B2 C1 VGND VNB VPB VPWR X
.ends

* Black-box entry subcircuit for sky130_fd_sc_hd__o2bb2a_2 abstract view
.subckt sky130_fd_sc_hd__o2bb2a_2 A1_N A2_N B1 B2 VGND VNB VPB VPWR X
.ends

* Black-box entry subcircuit for sky130_fd_sc_hd__mux2_4 abstract view
.subckt sky130_fd_sc_hd__mux2_4 A0 A1 S VGND VNB VPB VPWR X
.ends

* Black-box entry subcircuit for sky130_fd_sc_hd__xor2_2 abstract view
.subckt sky130_fd_sc_hd__xor2_2 A B VGND VNB VPB VPWR X
.ends

* Black-box entry subcircuit for sky130_fd_sc_hd__o221a_4 abstract view
.subckt sky130_fd_sc_hd__o221a_4 A1 A2 B1 B2 C1 VGND VNB VPB VPWR X
.ends

* Black-box entry subcircuit for sky130_fd_sc_hd__buf_4 abstract view
.subckt sky130_fd_sc_hd__buf_4 A VGND VNB VPB VPWR X
.ends

* Black-box entry subcircuit for sky130_fd_sc_hd__a21o_2 abstract view
.subckt sky130_fd_sc_hd__a21o_2 A1 A2 B1 VGND VNB VPB VPWR X
.ends

* Black-box entry subcircuit for sky130_fd_sc_hd__a32o_2 abstract view
.subckt sky130_fd_sc_hd__a32o_2 A1 A2 A3 B1 B2 VGND VNB VPB VPWR X
.ends

* Black-box entry subcircuit for sky130_fd_sc_hd__tapvpwrvgnd_1 abstract view
.subckt sky130_fd_sc_hd__tapvpwrvgnd_1 VGND VPWR
.ends

* Black-box entry subcircuit for sky130_fd_sc_hd__a31o_2 abstract view
.subckt sky130_fd_sc_hd__a31o_2 A1 A2 A3 B1 VGND VNB VPB VPWR X
.ends

* Black-box entry subcircuit for sky130_fd_sc_hd__or2_2 abstract view
.subckt sky130_fd_sc_hd__or2_2 A B VGND VNB VPB VPWR X
.ends

* Black-box entry subcircuit for sky130_fd_sc_hd__buf_2 abstract view
.subckt sky130_fd_sc_hd__buf_2 A VGND VNB VPB VPWR X
.ends

* Black-box entry subcircuit for sky130_fd_sc_hd__a22o_4 abstract view
.subckt sky130_fd_sc_hd__a22o_4 A1 A2 B1 B2 VGND VNB VPB VPWR X
.ends

* Black-box entry subcircuit for sky130_fd_sc_hd__or4_4 abstract view
.subckt sky130_fd_sc_hd__or4_4 A B C D VGND VNB VPB VPWR X
.ends

* Black-box entry subcircuit for sky130_fd_sc_hd__a31o_4 abstract view
.subckt sky130_fd_sc_hd__a31o_4 A1 A2 A3 B1 VGND VNB VPB VPWR X
.ends

* Black-box entry subcircuit for sky130_fd_sc_hd__clkbuf_2 abstract view
.subckt sky130_fd_sc_hd__clkbuf_2 A VGND VNB VPB VPWR X
.ends

* Black-box entry subcircuit for sky130_fd_sc_hd__or2b_2 abstract view
.subckt sky130_fd_sc_hd__or2b_2 A B_N VGND VNB VPB VPWR X
.ends

* Black-box entry subcircuit for sky130_fd_sc_hd__o21ai_4 abstract view
.subckt sky130_fd_sc_hd__o21ai_4 A1 A2 B1 VGND VNB VPB VPWR Y
.ends

* Black-box entry subcircuit for sky130_fd_sc_hd__and2_4 abstract view
.subckt sky130_fd_sc_hd__and2_4 A B VGND VNB VPB VPWR X
.ends

* Black-box entry subcircuit for sky130_fd_sc_hd__a21oi_2 abstract view
.subckt sky130_fd_sc_hd__a21oi_2 A1 A2 B1 VGND VNB VPB VPWR Y
.ends

* Black-box entry subcircuit for sky130_fd_sc_hd__inv_2 abstract view
.subckt sky130_fd_sc_hd__inv_2 A VGND VNB VPB VPWR Y
.ends

* Black-box entry subcircuit for sky130_fd_sc_hd__nand2_2 abstract view
.subckt sky130_fd_sc_hd__nand2_2 A B VGND VNB VPB VPWR Y
.ends

* Black-box entry subcircuit for sky130_fd_sc_hd__and3_4 abstract view
.subckt sky130_fd_sc_hd__and3_4 A B C VGND VNB VPB VPWR X
.ends

* Black-box entry subcircuit for sky130_fd_sc_hd__clkdlybuf4s25_1 abstract view
.subckt sky130_fd_sc_hd__clkdlybuf4s25_1 A VGND VNB VPB VPWR X
.ends

* Black-box entry subcircuit for sky130_fd_sc_hd__o22a_4 abstract view
.subckt sky130_fd_sc_hd__o22a_4 A1 A2 B1 B2 VGND VNB VPB VPWR X
.ends

* Black-box entry subcircuit for sky130_fd_sc_hd__o211ai_2 abstract view
.subckt sky130_fd_sc_hd__o211ai_2 A1 A2 B1 C1 VGND VNB VPB VPWR Y
.ends

* Black-box entry subcircuit for sky130_fd_sc_hd__a21bo_2 abstract view
.subckt sky130_fd_sc_hd__a21bo_2 A1 A2 B1_N VGND VNB VPB VPWR X
.ends

* Black-box entry subcircuit for sky130_fd_sc_hd__a22o_2 abstract view
.subckt sky130_fd_sc_hd__a22o_2 A1 A2 B1 B2 VGND VNB VPB VPWR X
.ends

* Black-box entry subcircuit for sky130_fd_sc_hd__o31a_2 abstract view
.subckt sky130_fd_sc_hd__o31a_2 A1 A2 A3 B1 VGND VNB VPB VPWR X
.ends

* Black-box entry subcircuit for sky130_fd_sc_hd__o21a_2 abstract view
.subckt sky130_fd_sc_hd__o21a_2 A1 A2 B1 VGND VNB VPB VPWR X
.ends

* Black-box entry subcircuit for sky130_fd_sc_hd__and2b_2 abstract view
.subckt sky130_fd_sc_hd__and2b_2 A_N B VGND VNB VPB VPWR X
.ends

* Black-box entry subcircuit for sky130_fd_sc_hd__a211o_2 abstract view
.subckt sky130_fd_sc_hd__a211o_2 A1 A2 B1 C1 VGND VNB VPB VPWR X
.ends

* Black-box entry subcircuit for sky130_fd_sc_hd__a211oi_2 abstract view
.subckt sky130_fd_sc_hd__a211oi_2 A1 A2 B1 C1 VGND VNB VPB VPWR Y
.ends

* Black-box entry subcircuit for sky130_fd_sc_hd__o22a_2 abstract view
.subckt sky130_fd_sc_hd__o22a_2 A1 A2 B1 B2 VGND VNB VPB VPWR X
.ends

* Black-box entry subcircuit for sky130_fd_sc_hd__or3b_4 abstract view
.subckt sky130_fd_sc_hd__or3b_4 A B C_N VGND VNB VPB VPWR X
.ends

* Black-box entry subcircuit for sky130_fd_sc_hd__mux2_2 abstract view
.subckt sky130_fd_sc_hd__mux2_2 A0 A1 S VGND VNB VPB VPWR X
.ends

* Black-box entry subcircuit for sky130_fd_sc_hd__o2bb2a_4 abstract view
.subckt sky130_fd_sc_hd__o2bb2a_4 A1_N A2_N B1 B2 VGND VNB VPB VPWR X
.ends

* Black-box entry subcircuit for sky130_fd_sc_hd__nor2_2 abstract view
.subckt sky130_fd_sc_hd__nor2_2 A B VGND VNB VPB VPWR Y
.ends

* Black-box entry subcircuit for sky130_fd_sc_hd__nand3_2 abstract view
.subckt sky130_fd_sc_hd__nand3_2 A B C VGND VNB VPB VPWR Y
.ends

* Black-box entry subcircuit for sky130_fd_sc_hd__and4_2 abstract view
.subckt sky130_fd_sc_hd__and4_2 A B C D VGND VNB VPB VPWR X
.ends

* Black-box entry subcircuit for sky130_fd_sc_hd__a2111o_2 abstract view
.subckt sky130_fd_sc_hd__a2111o_2 A1 A2 B1 C1 D1 VGND VNB VPB VPWR X
.ends

* Black-box entry subcircuit for sky130_fd_sc_hd__a311o_4 abstract view
.subckt sky130_fd_sc_hd__a311o_4 A1 A2 A3 B1 C1 VGND VNB VPB VPWR X
.ends

* Black-box entry subcircuit for sky130_fd_sc_hd__or2_4 abstract view
.subckt sky130_fd_sc_hd__or2_4 A B VGND VNB VPB VPWR X
.ends

* Black-box entry subcircuit for sky130_fd_sc_hd__a31oi_4 abstract view
.subckt sky130_fd_sc_hd__a31oi_4 A1 A2 A3 B1 VGND VNB VPB VPWR Y
.ends

* Black-box entry subcircuit for sky130_fd_sc_hd__and3b_2 abstract view
.subckt sky130_fd_sc_hd__and3b_2 A_N B C VGND VNB VPB VPWR X
.ends

* Black-box entry subcircuit for sky130_fd_sc_hd__a21boi_2 abstract view
.subckt sky130_fd_sc_hd__a21boi_2 A1 A2 B1_N VGND VNB VPB VPWR Y
.ends

* Black-box entry subcircuit for sky130_fd_sc_hd__o21bai_4 abstract view
.subckt sky130_fd_sc_hd__o21bai_4 A1 A2 B1_N VGND VNB VPB VPWR Y
.ends

* Black-box entry subcircuit for sky130_fd_sc_hd__nor2_4 abstract view
.subckt sky130_fd_sc_hd__nor2_4 A B VGND VNB VPB VPWR Y
.ends

* Black-box entry subcircuit for sky130_fd_sc_hd__or4b_4 abstract view
.subckt sky130_fd_sc_hd__or4b_4 A B C D_N VGND VNB VPB VPWR X
.ends

* Black-box entry subcircuit for sky130_fd_sc_hd__buf_12 abstract view
.subckt sky130_fd_sc_hd__buf_12 A VGND VNB VPB VPWR X
.ends

* Black-box entry subcircuit for sky130_fd_sc_hd__o211a_2 abstract view
.subckt sky130_fd_sc_hd__o211a_2 A1 A2 B1 C1 VGND VNB VPB VPWR X
.ends

* Black-box entry subcircuit for sky130_fd_sc_hd__and4_4 abstract view
.subckt sky130_fd_sc_hd__and4_4 A B C D VGND VNB VPB VPWR X
.ends

* Black-box entry subcircuit for sky130_fd_sc_hd__and3_2 abstract view
.subckt sky130_fd_sc_hd__and3_2 A B C VGND VNB VPB VPWR X
.ends

* Black-box entry subcircuit for sky130_fd_sc_hd__or2b_4 abstract view
.subckt sky130_fd_sc_hd__or2b_4 A B_N VGND VNB VPB VPWR X
.ends

* Black-box entry subcircuit for sky130_fd_sc_hd__o21ai_2 abstract view
.subckt sky130_fd_sc_hd__o21ai_2 A1 A2 B1 VGND VNB VPB VPWR Y
.ends

* Black-box entry subcircuit for sky130_fd_sc_hd__clkbuf_4 abstract view
.subckt sky130_fd_sc_hd__clkbuf_4 A VGND VNB VPB VPWR X
.ends

* Black-box entry subcircuit for sky130_fd_sc_hd__o21ba_2 abstract view
.subckt sky130_fd_sc_hd__o21ba_2 A1 A2 B1_N VGND VNB VPB VPWR X
.ends

* Black-box entry subcircuit for sky130_fd_sc_hd__a2bb2o_2 abstract view
.subckt sky130_fd_sc_hd__a2bb2o_2 A1_N A2_N B1 B2 VGND VNB VPB VPWR X
.ends

* Black-box entry subcircuit for sky130_fd_sc_hd__nand3b_2 abstract view
.subckt sky130_fd_sc_hd__nand3b_2 A_N B C VGND VNB VPB VPWR Y
.ends

* Black-box entry subcircuit for sky130_fd_sc_hd__dlymetal6s2s_1 abstract view
.subckt sky130_fd_sc_hd__dlymetal6s2s_1 A VGND VNB VPB VPWR X
.ends

* Black-box entry subcircuit for sky130_fd_sc_hd__nand2_4 abstract view
.subckt sky130_fd_sc_hd__nand2_4 A B VGND VNB VPB VPWR Y
.ends

* Black-box entry subcircuit for sky130_fd_sc_hd__o21bai_2 abstract view
.subckt sky130_fd_sc_hd__o21bai_2 A1 A2 B1_N VGND VNB VPB VPWR Y
.ends

* Black-box entry subcircuit for sky130_fd_sc_hd__dlymetal6s4s_1 abstract view
.subckt sky130_fd_sc_hd__dlymetal6s4s_1 A VGND VNB VPB VPWR X
.ends

* Black-box entry subcircuit for sky130_fd_sc_hd__or3_4 abstract view
.subckt sky130_fd_sc_hd__or3_4 A B C VGND VNB VPB VPWR X
.ends

* Black-box entry subcircuit for sky130_fd_sc_hd__o32ai_4 abstract view
.subckt sky130_fd_sc_hd__o32ai_4 A1 A2 A3 B1 B2 VGND VNB VPB VPWR Y
.ends

* Black-box entry subcircuit for sky130_fd_sc_hd__nor3_2 abstract view
.subckt sky130_fd_sc_hd__nor3_2 A B C VGND VNB VPB VPWR Y
.ends

* Black-box entry subcircuit for sky130_fd_sc_hd__nor4_2 abstract view
.subckt sky130_fd_sc_hd__nor4_2 A B C D VGND VNB VPB VPWR Y
.ends

* Black-box entry subcircuit for sky130_fd_sc_hd__a211o_4 abstract view
.subckt sky130_fd_sc_hd__a211o_4 A1 A2 B1 C1 VGND VNB VPB VPWR X
.ends

* Black-box entry subcircuit for sky130_fd_sc_hd__o21ba_4 abstract view
.subckt sky130_fd_sc_hd__o21ba_4 A1 A2 B1_N VGND VNB VPB VPWR X
.ends

* Black-box entry subcircuit for sky130_fd_sc_hd__bufinv_8 abstract view
.subckt sky130_fd_sc_hd__bufinv_8 A VGND VNB VPB VPWR Y
.ends

* Black-box entry subcircuit for sky130_fd_sc_hd__dlygate4sd1_1 abstract view
.subckt sky130_fd_sc_hd__dlygate4sd1_1 A VGND VNB VPB VPWR X
.ends

* Black-box entry subcircuit for sky130_fd_sc_hd__a21oi_4 abstract view
.subckt sky130_fd_sc_hd__a21oi_4 A1 A2 B1 VGND VNB VPB VPWR Y
.ends

* Black-box entry subcircuit for sky130_fd_sc_hd__a31oi_2 abstract view
.subckt sky130_fd_sc_hd__a31oi_2 A1 A2 A3 B1 VGND VNB VPB VPWR Y
.ends

* Black-box entry subcircuit for sky130_fd_sc_hd__a21o_4 abstract view
.subckt sky130_fd_sc_hd__a21o_4 A1 A2 B1 VGND VNB VPB VPWR X
.ends

* Black-box entry subcircuit for sky130_fd_sc_hd__o221a_2 abstract view
.subckt sky130_fd_sc_hd__o221a_2 A1 A2 B1 B2 C1 VGND VNB VPB VPWR X
.ends

* Black-box entry subcircuit for sky130_fd_sc_hd__o211a_4 abstract view
.subckt sky130_fd_sc_hd__o211a_4 A1 A2 B1 C1 VGND VNB VPB VPWR X
.ends

* Black-box entry subcircuit for sky130_fd_sc_hd__nand2_8 abstract view
.subckt sky130_fd_sc_hd__nand2_8 A B VGND VNB VPB VPWR Y
.ends

* Black-box entry subcircuit for sky130_fd_sc_hd__a22oi_2 abstract view
.subckt sky130_fd_sc_hd__a22oi_2 A1 A2 B1 B2 VGND VNB VPB VPWR Y
.ends

* Black-box entry subcircuit for sky130_fd_sc_hd__and2_2 abstract view
.subckt sky130_fd_sc_hd__and2_2 A B VGND VNB VPB VPWR X
.ends

* Black-box entry subcircuit for sky130_fd_sc_hd__o31a_4 abstract view
.subckt sky130_fd_sc_hd__o31a_4 A1 A2 A3 B1 VGND VNB VPB VPWR X
.ends

* Black-box entry subcircuit for sky130_fd_sc_hd__nand3_4 abstract view
.subckt sky130_fd_sc_hd__nand3_4 A B C VGND VNB VPB VPWR Y
.ends

* Black-box entry subcircuit for sky130_fd_sc_hd__a21bo_4 abstract view
.subckt sky130_fd_sc_hd__a21bo_4 A1 A2 B1_N VGND VNB VPB VPWR X
.ends

* Black-box entry subcircuit for sky130_fd_sc_hd__or3_2 abstract view
.subckt sky130_fd_sc_hd__or3_2 A B C VGND VNB VPB VPWR X
.ends

* Black-box entry subcircuit for sky130_fd_sc_hd__inv_8 abstract view
.subckt sky130_fd_sc_hd__inv_8 A VGND VNB VPB VPWR Y
.ends

* Black-box entry subcircuit for sky130_fd_sc_hd__xor2_4 abstract view
.subckt sky130_fd_sc_hd__xor2_4 A B VGND VNB VPB VPWR X
.ends

* Black-box entry subcircuit for sky130_fd_sc_hd__nor3b_2 abstract view
.subckt sky130_fd_sc_hd__nor3b_2 A B C_N VGND VNB VPB VPWR Y
.ends

* Black-box entry subcircuit for sky130_fd_sc_hd__or3b_2 abstract view
.subckt sky130_fd_sc_hd__or3b_2 A B C_N VGND VNB VPB VPWR X
.ends

.subckt addsub32 A[0] A[10] A[11] A[12] A[13] A[14] A[15] A[16] A[17] A[18] A[19]
+ A[1] A[20] A[21] A[22] A[23] A[24] A[25] A[26] A[27] A[28] A[29] A[2] A[30] A[31]
+ A[3] A[4] A[5] A[6] A[7] A[8] A[9] B[0] B[10] B[11] B[12] B[13] B[14] B[15] B[16]
+ B[17] B[18] B[19] B[1] B[20] B[21] B[22] B[23] B[24] B[25] B[26] B[27] B[28] B[29]
+ B[2] B[30] B[31] B[3] B[4] B[5] B[6] B[7] B[8] B[9] S[0] S[10] S[11] S[12] S[13]
+ S[14] S[15] S[16] S[17] S[18] S[19] S[1] S[20] S[21] S[22] S[23] S[24] S[25] S[26]
+ S[27] S[28] S[29] S[2] S[30] S[31] S[3] S[4] S[5] S[6] S[7] S[8] S[9] VGND VPWR
+ carryOut sub
XFILLER_22_122 VGND VGND VPWR VPWR sky130_fd_sc_hd__decap_3
XFILLER_13_111 VGND VGND VPWR VPWR sky130_fd_sc_hd__fill_1
XFILLER_13_122 VGND VGND VPWR VPWR sky130_fd_sc_hd__decap_3
X_501_ _515_/B _518_/B VGND VGND VPWR VPWR _521_/C sky130_fd_sc_hd__xnor2_2
X_432_ _432_/A _437_/C VGND VGND VPWR VPWR _432_/Y sky130_fd_sc_hd__xnor2_4
XFILLER_26_63 VGND VGND VPWR VPWR sky130_fd_sc_hd__decap_3
XFILLER_26_41 VGND VGND VPWR VPWR sky130_fd_sc_hd__decap_3
XFILLER_13_155 VGND VGND VPWR VPWR sky130_fd_sc_hd__fill_2
X_363_ _363_/A _737_/A _739_/B _739_/C VGND VGND VPWR VPWR _363_/Y sky130_fd_sc_hd__nand4_2
XFILLER_9_148 VGND VGND VPWR VPWR sky130_fd_sc_hd__decap_3
XFILLER_3_12 VGND VGND VPWR VPWR sky130_fd_sc_hd__decap_3
XFILLER_36_203 VGND VGND VPWR VPWR sky130_fd_sc_hd__decap_3
XFILLER_8_192 VGND VGND VPWR VPWR sky130_fd_sc_hd__decap_3
Xfanout105 fanout107/X VGND VGND VPWR VPWR fanout105/X sky130_fd_sc_hd__buf_8
Xfanout116 _679_/C1 VGND VGND VPWR VPWR _644_/A sky130_fd_sc_hd__buf_6
XFILLER_10_103 VGND VGND VPWR VPWR sky130_fd_sc_hd__decap_3
XFILLER_10_147 VGND VGND VPWR VPWR sky130_fd_sc_hd__decap_3
X_415_ _393_/X _379_/A _394_/X _390_/A _401_/A VGND VGND VPWR VPWR _417_/B sky130_fd_sc_hd__a221o_2
XFILLER_5_140 VGND VGND VPWR VPWR sky130_fd_sc_hd__decap_3
XFILLER_5_195 VGND VGND VPWR VPWR sky130_fd_sc_hd__fill_2
XFILLER_30_209 VGND VGND VPWR VPWR sky130_fd_sc_hd__fill_2
XFILLER_23_42 VGND VGND VPWR VPWR sky130_fd_sc_hd__decap_3
XFILLER_23_31 VGND VGND VPWR VPWR sky130_fd_sc_hd__decap_3
XFILLER_0_57 VGND VGND VPWR VPWR sky130_fd_sc_hd__decap_3
XFILLER_9_88 VGND VGND VPWR VPWR sky130_fd_sc_hd__decap_3
XFILLER_9_66 VGND VGND VPWR VPWR sky130_fd_sc_hd__fill_2
XFILLER_9_55 VGND VGND VPWR VPWR sky130_fd_sc_hd__fill_1
X_680_ _650_/A _675_/X _678_/X _679_/Y VGND VGND VPWR VPWR _680_/X sky130_fd_sc_hd__o2bb2a_2
XFILLER_34_85 VGND VGND VPWR VPWR sky130_fd_sc_hd__fill_2
XFILLER_29_128 VGND VGND VPWR VPWR sky130_fd_sc_hd__decap_3
XFILLER_29_106 VGND VGND VPWR VPWR sky130_fd_sc_hd__decap_3
XFILLER_20_76 VGND VGND VPWR VPWR sky130_fd_sc_hd__decap_3
XFILLER_20_43 VGND VGND VPWR VPWR sky130_fd_sc_hd__decap_3
X_732_ _730_/Y _731_/X _732_/S VGND VGND VPWR VPWR _742_/A sky130_fd_sc_hd__mux2_4
XFILLER_29_63 VGND VGND VPWR VPWR sky130_fd_sc_hd__decap_3
X_594_ _706_/B _594_/B VGND VGND VPWR VPWR _594_/X sky130_fd_sc_hd__xor2_2
X_663_ _554_/B _656_/X _659_/X _657_/Y _662_/X VGND VGND VPWR VPWR _663_/X sky130_fd_sc_hd__o221a_4
XFILLER_28_172 VGND VGND VPWR VPWR sky130_fd_sc_hd__decap_3
XFILLER_6_67 VGND VGND VPWR VPWR sky130_fd_sc_hd__fill_2
XFILLER_13_3 VGND VGND VPWR VPWR sky130_fd_sc_hd__fill_1
XFILLER_34_197 VGND VGND VPWR VPWR sky130_fd_sc_hd__decap_3
Xrebuffer129 _369_/X VGND VGND VPWR VPWR _630_/B1 sky130_fd_sc_hd__buf_6
XFILLER_1_208 VGND VGND VPWR VPWR sky130_fd_sc_hd__decap_3
XFILLER_15_32 VGND VGND VPWR VPWR sky130_fd_sc_hd__decap_3
XFILLER_25_153 VGND VGND VPWR VPWR sky130_fd_sc_hd__fill_1
XFILLER_25_131 VGND VGND VPWR VPWR sky130_fd_sc_hd__decap_3
XFILLER_15_98 VGND VGND VPWR VPWR sky130_fd_sc_hd__decap_3
XFILLER_31_53 VGND VGND VPWR VPWR sky130_fd_sc_hd__decap_3
XFILLER_31_20 VGND VGND VPWR VPWR sky130_fd_sc_hd__decap_3
Xoutput75 _399_/Y VGND VGND VPWR VPWR S[18] sky130_fd_sc_hd__buf_4
X_715_ _716_/A _714_/X _701_/A VGND VGND VPWR VPWR _715_/X sky130_fd_sc_hd__a21o_2
Xoutput97 _618_/Y VGND VGND VPWR VPWR S[9] sky130_fd_sc_hd__buf_6
Xoutput86 _530_/Y VGND VGND VPWR VPWR S[28] sky130_fd_sc_hd__buf_6
XFILLER_16_120 VGND VGND VPWR VPWR sky130_fd_sc_hd__decap_3
XFILLER_16_131 VGND VGND VPWR VPWR sky130_fd_sc_hd__decap_3
X_577_ _694_/A _695_/B VGND VGND VPWR VPWR _578_/A sky130_fd_sc_hd__xnor2_2
X_646_ _634_/Y _631_/A _631_/B _645_/B _668_/Y VGND VGND VPWR VPWR _646_/X sky130_fd_sc_hd__a32o_2
XTAP_TAPCELL_ROW_26_170 VGND VPWR sky130_fd_sc_hd__tapvpwrvgnd_1
XFILLER_31_167 VGND VGND VPWR VPWR sky130_fd_sc_hd__fill_1
XFILLER_31_101 VGND VGND VPWR VPWR sky130_fd_sc_hd__decap_3
XFILLER_22_178 VGND VGND VPWR VPWR sky130_fd_sc_hd__fill_1
XFILLER_22_134 VGND VGND VPWR VPWR sky130_fd_sc_hd__decap_3
XFILLER_22_101 VGND VGND VPWR VPWR sky130_fd_sc_hd__decap_3
X_500_ _500_/A _500_/B VGND VGND VPWR VPWR _500_/Y sky130_fd_sc_hd__xnor2_2
XFILLER_13_134 VGND VGND VPWR VPWR sky130_fd_sc_hd__decap_3
XFILLER_13_167 VGND VGND VPWR VPWR sky130_fd_sc_hd__fill_1
X_431_ _648_/A _441_/A VGND VGND VPWR VPWR _432_/A sky130_fd_sc_hd__xnor2_2
X_362_ _617_/A _357_/Y _358_/Y _361_/Y VGND VGND VPWR VPWR _369_/C sky130_fd_sc_hd__a31o_2
XFILLER_9_116 VGND VGND VPWR VPWR sky130_fd_sc_hd__decap_3
XFILLER_13_178 VGND VGND VPWR VPWR sky130_fd_sc_hd__decap_3
X_629_ _629_/A _629_/B VGND VGND VPWR VPWR _629_/Y sky130_fd_sc_hd__xnor2_2
XFILLER_36_215 VGND VGND VPWR VPWR sky130_fd_sc_hd__fill_2
XFILLER_8_182 VGND VGND VPWR VPWR sky130_fd_sc_hd__decap_3
XFILLER_8_171 VGND VGND VPWR VPWR sky130_fd_sc_hd__decap_3
XFILLER_10_115 VGND VGND VPWR VPWR sky130_fd_sc_hd__decap_3
XFILLER_12_55 VGND VGND VPWR VPWR sky130_fd_sc_hd__decap_3
XFILLER_18_215 VGND VGND VPWR VPWR sky130_fd_sc_hd__fill_2
X_414_ _423_/A _414_/B VGND VGND VPWR VPWR _414_/X sky130_fd_sc_hd__or2_2
XFILLER_5_152 VGND VGND VPWR VPWR sky130_fd_sc_hd__fill_2
XPHY_EDGE_ROW_12_Right_12 VGND VGND VPWR VPWR sky130_fd_sc_hd__decap_3
XPHY_EDGE_ROW_21_Right_21 VGND VGND VPWR VPWR sky130_fd_sc_hd__decap_3
XFILLER_23_54 VGND VGND VPWR VPWR sky130_fd_sc_hd__fill_2
XPHY_EDGE_ROW_30_Right_30 VGND VGND VPWR VPWR sky130_fd_sc_hd__decap_3
XFILLER_23_87 VGND VGND VPWR VPWR sky130_fd_sc_hd__decap_3
XFILLER_2_177 VGND VGND VPWR VPWR sky130_fd_sc_hd__decap_3
XFILLER_18_32 VGND VGND VPWR VPWR sky130_fd_sc_hd__decap_3
XFILLER_18_65 VGND VGND VPWR VPWR sky130_fd_sc_hd__decap_3
XFILLER_34_42 VGND VGND VPWR VPWR sky130_fd_sc_hd__decap_3
Xload_slew117 _644_/A VGND VGND VPWR VPWR _617_/A sky130_fd_sc_hd__buf_2
Xload_slew106 fanout105/X VGND VGND VPWR VPWR _666_/A sky130_fd_sc_hd__buf_8
X_662_ _656_/X _554_/B _660_/X _661_/Y VGND VGND VPWR VPWR _662_/X sky130_fd_sc_hd__a22o_4
X_731_ _731_/A _731_/B _731_/C _731_/D VGND VGND VPWR VPWR _731_/X sky130_fd_sc_hd__or4_4
XFILLER_29_86 VGND VGND VPWR VPWR sky130_fd_sc_hd__decap_3
X_593_ _457_/A _593_/A2 _590_/Y _592_/X VGND VGND VPWR VPWR _594_/B sky130_fd_sc_hd__a31o_4
XFILLER_28_184 VGND VGND VPWR VPWR sky130_fd_sc_hd__decap_3
XFILLER_6_57 VGND VGND VPWR VPWR sky130_fd_sc_hd__decap_3
XFILLER_34_176 VGND VGND VPWR VPWR sky130_fd_sc_hd__decap_3
XPHY_EDGE_ROW_6_Right_6 VGND VGND VPWR VPWR sky130_fd_sc_hd__decap_3
Xoutput98 _663_/X VGND VGND VPWR VPWR carryOut sky130_fd_sc_hd__buf_8
Xoutput87 _536_/Y VGND VGND VPWR VPWR S[29] sky130_fd_sc_hd__buf_4
Xoutput76 _406_/Y VGND VGND VPWR VPWR S[19] sky130_fd_sc_hd__clkbuf_2
XFILLER_31_98 VGND VGND VPWR VPWR sky130_fd_sc_hd__decap_3
X_645_ _668_/Y _645_/B VGND VGND VPWR VPWR _645_/X sky130_fd_sc_hd__or2_2
X_714_ _716_/B _703_/B VGND VGND VPWR VPWR _714_/X sky130_fd_sc_hd__or2b_2
XFILLER_16_154 VGND VGND VPWR VPWR sky130_fd_sc_hd__decap_3
X_576_ _622_/A _694_/B _575_/X VGND VGND VPWR VPWR _581_/B sky130_fd_sc_hd__o21ai_4
XTAP_TAPCELL_ROW_26_171 VGND VPWR sky130_fd_sc_hd__tapvpwrvgnd_1
XFILLER_31_179 VGND VGND VPWR VPWR sky130_fd_sc_hd__decap_3
XFILLER_31_146 VGND VGND VPWR VPWR sky130_fd_sc_hd__decap_3
XFILLER_31_113 VGND VGND VPWR VPWR sky130_fd_sc_hd__fill_1
XFILLER_22_113 VGND VGND VPWR VPWR sky130_fd_sc_hd__decap_3
XFILLER_26_32 VGND VGND VPWR VPWR sky130_fd_sc_hd__fill_1
XFILLER_26_21 VGND VGND VPWR VPWR sky130_fd_sc_hd__decap_3
XFILLER_13_113 VGND VGND VPWR VPWR sky130_fd_sc_hd__decap_3
XFILLER_13_146 VGND VGND VPWR VPWR sky130_fd_sc_hd__decap_3
X_430_ _440_/A _440_/B VGND VGND VPWR VPWR _441_/A sky130_fd_sc_hd__and2_4
X_361_ _733_/A _359_/X _360_/X VGND VGND VPWR VPWR _361_/Y sky130_fd_sc_hd__a21oi_2
XFILLER_9_128 VGND VGND VPWR VPWR sky130_fd_sc_hd__decap_3
XFILLER_9_106 VGND VGND VPWR VPWR sky130_fd_sc_hd__decap_3
XFILLER_26_54 VGND VGND VPWR VPWR sky130_fd_sc_hd__decap_3
X_628_ _736_/B _628_/B VGND VGND VPWR VPWR _629_/B sky130_fd_sc_hd__xor2_2
X_559_ _559_/A VGND VGND VPWR VPWR _560_/A sky130_fd_sc_hd__inv_2
XFILLER_8_150 VGND VGND VPWR VPWR sky130_fd_sc_hd__decap_3
Xfanout107 input65/X VGND VGND VPWR VPWR fanout107/X sky130_fd_sc_hd__buf_6
Xfanout118 input65/X VGND VGND VPWR VPWR _679_/C1 sky130_fd_sc_hd__clkbuf_2
XTAP_TAPCELL_ROW_3_90 VGND VPWR sky130_fd_sc_hd__tapvpwrvgnd_1
XFILLER_10_127 VGND VGND VPWR VPWR sky130_fd_sc_hd__decap_3
XFILLER_12_78 VGND VGND VPWR VPWR sky130_fd_sc_hd__decap_3
XFILLER_5_6 VGND VGND VPWR VPWR sky130_fd_sc_hd__fill_1
X_413_ _413_/A _414_/B VGND VGND VPWR VPWR _413_/Y sky130_fd_sc_hd__nand2_2
XFILLER_3_3 VGND VGND VPWR VPWR sky130_fd_sc_hd__decap_3
XFILLER_2_156 VGND VGND VPWR VPWR sky130_fd_sc_hd__fill_2
XFILLER_23_99 VGND VGND VPWR VPWR sky130_fd_sc_hd__decap_3
XFILLER_0_15 VGND VGND VPWR VPWR sky130_fd_sc_hd__decap_3
XFILLER_2_189 VGND VGND VPWR VPWR sky130_fd_sc_hd__decap_3
XFILLER_9_57 VGND VGND VPWR VPWR sky130_fd_sc_hd__decap_3
XFILLER_9_46 VGND VGND VPWR VPWR sky130_fd_sc_hd__decap_3
XTAP_TAPCELL_ROW_0_80 VGND VPWR sky130_fd_sc_hd__tapvpwrvgnd_1
XFILLER_18_77 VGND VGND VPWR VPWR sky130_fd_sc_hd__decap_3
XFILLER_18_88 VGND VGND VPWR VPWR sky130_fd_sc_hd__decap_3
XFILLER_34_32 VGND VGND VPWR VPWR sky130_fd_sc_hd__fill_2
XPHY_EDGE_ROW_28_Left_65 VGND VGND VPWR VPWR sky130_fd_sc_hd__decap_3
XPHY_EDGE_ROW_12_Left_49 VGND VGND VPWR VPWR sky130_fd_sc_hd__decap_3
X_592_ _596_/A _592_/B _592_/C VGND VGND VPWR VPWR _592_/X sky130_fd_sc_hd__and3_4
X_661_ _661_/A _661_/B VGND VGND VPWR VPWR _661_/Y sky130_fd_sc_hd__nand2_2
X_730_ _731_/D _730_/B _730_/C _730_/D VGND VGND VPWR VPWR _730_/Y sky130_fd_sc_hd__nand4_2
XTAP_TAPCELL_ROW_29_180 VGND VPWR sky130_fd_sc_hd__tapvpwrvgnd_1
XFILLER_19_185 VGND VGND VPWR VPWR sky130_fd_sc_hd__decap_3
XFILLER_15_23 VGND VGND VPWR VPWR sky130_fd_sc_hd__decap_3
XFILLER_15_78 VGND VGND VPWR VPWR sky130_fd_sc_hd__decap_3
XFILLER_25_122 VGND VGND VPWR VPWR sky130_fd_sc_hd__decap_3
XFILLER_31_44 VGND VGND VPWR VPWR sky130_fd_sc_hd__decap_3
Xoutput88 _578_/Y VGND VGND VPWR VPWR S[2] sky130_fd_sc_hd__buf_6
Xoutput77 _571_/Y VGND VGND VPWR VPWR S[1] sky130_fd_sc_hd__buf_6
Xoutput66 _567_/Y VGND VGND VPWR VPWR S[0] sky130_fd_sc_hd__clkdlybuf4s25_1
XFILLER_16_111 VGND VGND VPWR VPWR sky130_fd_sc_hd__decap_3
XFILLER_16_166 VGND VGND VPWR VPWR sky130_fd_sc_hd__decap_3
X_575_ _689_/A _572_/X _574_/X _569_/A VGND VGND VPWR VPWR _575_/X sky130_fd_sc_hd__o22a_4
X_644_ _644_/A _728_/B VGND VGND VPWR VPWR _645_/B sky130_fd_sc_hd__xnor2_2
X_713_ _713_/A VGND VGND VPWR VPWR _716_/A sky130_fd_sc_hd__inv_2
XFILLER_31_169 VGND VGND VPWR VPWR sky130_fd_sc_hd__decap_3
XFILLER_31_125 VGND VGND VPWR VPWR sky130_fd_sc_hd__decap_3
XFILLER_22_125 VGND VGND VPWR VPWR sky130_fd_sc_hd__decap_3
XPHY_EDGE_ROW_15_Left_52 VGND VGND VPWR VPWR sky130_fd_sc_hd__decap_3
XFILLER_30_180 VGND VGND VPWR VPWR sky130_fd_sc_hd__decap_3
XFILLER_26_66 VGND VGND VPWR VPWR sky130_fd_sc_hd__decap_3
XFILLER_13_125 VGND VGND VPWR VPWR sky130_fd_sc_hd__decap_3
XFILLER_13_169 VGND VGND VPWR VPWR sky130_fd_sc_hd__decap_3
X_360_ _733_/B _734_/A _734_/B _617_/A VGND VGND VPWR VPWR _360_/X sky130_fd_sc_hd__a31o_2
XFILLER_3_15 VGND VGND VPWR VPWR sky130_fd_sc_hd__decap_3
XFILLER_36_206 VGND VGND VPWR VPWR sky130_fd_sc_hd__decap_3
X_558_ _550_/A _550_/B _559_/A _657_/A VGND VGND VPWR VPWR _563_/A sky130_fd_sc_hd__o211ai_2
X_627_ _626_/X _618_/A _369_/C VGND VGND VPWR VPWR _629_/A sky130_fd_sc_hd__a21bo_2
X_489_ _489_/A _491_/B VGND VGND VPWR VPWR _489_/X sky130_fd_sc_hd__or2b_2
XFILLER_8_195 VGND VGND VPWR VPWR sky130_fd_sc_hd__fill_1
Xfanout108 _709_/A VGND VGND VPWR VPWR _569_/A sky130_fd_sc_hd__buf_4
XFILLER_10_106 VGND VGND VPWR VPWR sky130_fd_sc_hd__decap_3
XFILLER_12_13 VGND VGND VPWR VPWR sky130_fd_sc_hd__decap_3
XPHY_EDGE_ROW_0_Left_37 VGND VGND VPWR VPWR sky130_fd_sc_hd__decap_3
X_412_ _401_/A _395_/X _410_/Y _411_/X VGND VGND VPWR VPWR _418_/C sky130_fd_sc_hd__a22o_2
XFILLER_5_110 VGND VGND VPWR VPWR sky130_fd_sc_hd__fill_2
XFILLER_5_143 VGND VGND VPWR VPWR sky130_fd_sc_hd__decap_3
XFILLER_4_80 VGND VGND VPWR VPWR sky130_fd_sc_hd__decap_3
XFILLER_23_45 VGND VGND VPWR VPWR sky130_fd_sc_hd__decap_3
XFILLER_23_34 VGND VGND VPWR VPWR sky130_fd_sc_hd__fill_2
XFILLER_9_36 VGND VGND VPWR VPWR sky130_fd_sc_hd__decap_3
XFILLER_29_3 VGND VGND VPWR VPWR sky130_fd_sc_hd__fill_1
XFILLER_1_190 VGND VGND VPWR VPWR sky130_fd_sc_hd__decap_3
XPHY_EDGE_ROW_3_Left_40 VGND VGND VPWR VPWR sky130_fd_sc_hd__decap_3
XFILLER_29_109 VGND VGND VPWR VPWR sky130_fd_sc_hd__decap_3
XFILLER_1_92 VGND VGND VPWR VPWR sky130_fd_sc_hd__decap_3
XFILLER_20_79 VGND VGND VPWR VPWR sky130_fd_sc_hd__decap_3
XFILLER_20_46 VGND VGND VPWR VPWR sky130_fd_sc_hd__fill_1
X_591_ _591_/A _591_/B VGND VGND VPWR VPWR _592_/C sky130_fd_sc_hd__nand2_2
X_660_ _661_/A _661_/B VGND VGND VPWR VPWR _660_/X sky130_fd_sc_hd__or2_2
XFILLER_29_66 VGND VGND VPWR VPWR sky130_fd_sc_hd__decap_3
XFILLER_28_197 VGND VGND VPWR VPWR sky130_fd_sc_hd__decap_3
XFILLER_28_175 VGND VGND VPWR VPWR sky130_fd_sc_hd__decap_3
XFILLER_19_131 VGND VGND VPWR VPWR sky130_fd_sc_hd__decap_3
XTAP_TAPCELL_ROW_29_181 VGND VPWR sky130_fd_sc_hd__tapvpwrvgnd_1
XFILLER_15_35 VGND VGND VPWR VPWR sky130_fd_sc_hd__fill_1
XFILLER_25_178 VGND VGND VPWR VPWR sky130_fd_sc_hd__fill_2
XFILLER_25_134 VGND VGND VPWR VPWR sky130_fd_sc_hd__fill_1
XFILLER_31_23 VGND VGND VPWR VPWR sky130_fd_sc_hd__fill_1
XFILLER_0_200 VGND VGND VPWR VPWR sky130_fd_sc_hd__decap_3
X_712_ _739_/A _702_/A _707_/B _711_/Y VGND VGND VPWR VPWR _712_/X sky130_fd_sc_hd__o31a_2
Xoutput89 _553_/Y VGND VGND VPWR VPWR S[30] sky130_fd_sc_hd__buf_6
Xoutput78 _432_/Y VGND VGND VPWR VPWR S[20] sky130_fd_sc_hd__buf_6
Xoutput67 _625_/X VGND VGND VPWR VPWR S[10] sky130_fd_sc_hd__buf_6
XFILLER_16_123 VGND VGND VPWR VPWR sky130_fd_sc_hd__decap_3
XFILLER_16_134 VGND VGND VPWR VPWR sky130_fd_sc_hd__fill_1
X_574_ _568_/B _565_/A _573_/X VGND VGND VPWR VPWR _574_/X sky130_fd_sc_hd__o21a_2
X_643_ _644_/A _729_/B _641_/X _642_/Y VGND VGND VPWR VPWR _643_/X sky130_fd_sc_hd__a31o_2
XFILLER_31_104 VGND VGND VPWR VPWR sky130_fd_sc_hd__decap_3
XFILLER_31_137 VGND VGND VPWR VPWR sky130_fd_sc_hd__decap_3
XFILLER_11_3 VGND VGND VPWR VPWR sky130_fd_sc_hd__fill_1
XFILLER_22_137 VGND VGND VPWR VPWR sky130_fd_sc_hd__decap_3
XFILLER_22_104 VGND VGND VPWR VPWR sky130_fd_sc_hd__decap_3
XFILLER_7_91 VGND VGND VPWR VPWR sky130_fd_sc_hd__decap_3
XFILLER_13_137 VGND VGND VPWR VPWR sky130_fd_sc_hd__fill_1
XFILLER_9_119 VGND VGND VPWR VPWR sky130_fd_sc_hd__decap_3
X_557_ _656_/A VGND VGND VPWR VPWR _657_/A sky130_fd_sc_hd__inv_2
X_626_ _735_/X _739_/X VGND VGND VPWR VPWR _626_/X sky130_fd_sc_hd__or2b_2
X_488_ _477_/A _666_/A VGND VGND VPWR VPWR _488_/X sky130_fd_sc_hd__and2b_2
XFILLER_8_141 VGND VGND VPWR VPWR sky130_fd_sc_hd__decap_3
XFILLER_10_118 VGND VGND VPWR VPWR sky130_fd_sc_hd__decap_3
XFILLER_12_36 VGND VGND VPWR VPWR sky130_fd_sc_hd__decap_3
XFILLER_12_58 VGND VGND VPWR VPWR sky130_fd_sc_hd__decap_3
X_411_ _414_/B _417_/A _413_/A _397_/A VGND VGND VPWR VPWR _411_/X sky130_fd_sc_hd__a211o_2
X_609_ _609_/A _724_/Y VGND VGND VPWR VPWR _610_/A sky130_fd_sc_hd__nand2_2
XFILLER_23_57 VGND VGND VPWR VPWR sky130_fd_sc_hd__decap_3
XFILLER_18_35 VGND VGND VPWR VPWR sky130_fd_sc_hd__decap_3
XFILLER_18_68 VGND VGND VPWR VPWR sky130_fd_sc_hd__decap_3
XFILLER_34_23 VGND VGND VPWR VPWR sky130_fd_sc_hd__decap_3
Xload_slew109 _569_/A VGND VGND VPWR VPWR _596_/A sky130_fd_sc_hd__buf_4
X_590_ _591_/A _592_/B VGND VGND VPWR VPWR _590_/Y sky130_fd_sc_hd__nand2_2
XFILLER_29_89 VGND VGND VPWR VPWR sky130_fd_sc_hd__decap_3
XFILLER_28_187 VGND VGND VPWR VPWR sky130_fd_sc_hd__decap_3
XFILLER_34_179 VGND VGND VPWR VPWR sky130_fd_sc_hd__decap_3
XFILLER_34_146 VGND VGND VPWR VPWR sky130_fd_sc_hd__fill_1
XFILLER_25_113 VGND VGND VPWR VPWR sky130_fd_sc_hd__decap_3
XFILLER_31_35 VGND VGND VPWR VPWR sky130_fd_sc_hd__decap_3
XFILLER_0_212 VGND VGND VPWR VPWR sky130_fd_sc_hd__decap_3
XFILLER_31_57 VGND VGND VPWR VPWR sky130_fd_sc_hd__decap_3
X_642_ _728_/B _728_/A _729_/B _644_/A VGND VGND VPWR VPWR _642_/Y sky130_fd_sc_hd__a211oi_2
X_711_ _724_/A _709_/B _702_/A _732_/S VGND VGND VPWR VPWR _711_/Y sky130_fd_sc_hd__o211ai_2
Xoutput79 _439_/Y VGND VGND VPWR VPWR S[21] sky130_fd_sc_hd__buf_6
Xoutput68 _629_/Y VGND VGND VPWR VPWR S[11] sky130_fd_sc_hd__buf_6
XFILLER_16_102 VGND VGND VPWR VPWR sky130_fd_sc_hd__decap_3
XFILLER_16_157 VGND VGND VPWR VPWR sky130_fd_sc_hd__decap_3
X_573_ _568_/B _565_/A _568_/A VGND VGND VPWR VPWR _573_/X sky130_fd_sc_hd__a21o_2
XPHY_EDGE_ROW_19_Right_19 VGND VGND VPWR VPWR sky130_fd_sc_hd__decap_3
XFILLER_31_149 VGND VGND VPWR VPWR sky130_fd_sc_hd__decap_3
XFILLER_24_190 VGND VGND VPWR VPWR sky130_fd_sc_hd__decap_3
XPHY_EDGE_ROW_28_Right_28 VGND VGND VPWR VPWR sky130_fd_sc_hd__decap_3
XFILLER_22_116 VGND VGND VPWR VPWR sky130_fd_sc_hd__decap_3
XTAP_TAPCELL_ROW_9_109 VGND VPWR sky130_fd_sc_hd__tapvpwrvgnd_1
XFILLER_13_105 VGND VGND VPWR VPWR sky130_fd_sc_hd__decap_3
XFILLER_13_116 VGND VGND VPWR VPWR sky130_fd_sc_hd__decap_3
XFILLER_13_149 VGND VGND VPWR VPWR sky130_fd_sc_hd__decap_3
XFILLER_26_57 VGND VGND VPWR VPWR sky130_fd_sc_hd__decap_3
XFILLER_26_24 VGND VGND VPWR VPWR sky130_fd_sc_hd__decap_3
XFILLER_9_109 VGND VGND VPWR VPWR sky130_fd_sc_hd__decap_3
X_625_ _739_/B _625_/B VGND VGND VPWR VPWR _625_/X sky130_fd_sc_hd__xor2_2
X_556_ _556_/A _556_/B VGND VGND VPWR VPWR _564_/B sky130_fd_sc_hd__or2_2
X_487_ _491_/B _489_/A _477_/A VGND VGND VPWR VPWR _487_/X sky130_fd_sc_hd__o21a_2
XFILLER_12_193 VGND VGND VPWR VPWR sky130_fd_sc_hd__decap_3
XFILLER_8_197 VGND VGND VPWR VPWR sky130_fd_sc_hd__fill_2
XFILLER_8_153 VGND VGND VPWR VPWR sky130_fd_sc_hd__fill_2
XTAP_TAPCELL_ROW_20_147 VGND VPWR sky130_fd_sc_hd__tapvpwrvgnd_1
X_410_ _414_/B _409_/Y _413_/A _397_/A VGND VGND VPWR VPWR _410_/Y sky130_fd_sc_hd__o211ai_2
XFILLER_5_167 VGND VGND VPWR VPWR sky130_fd_sc_hd__fill_1
X_608_ _724_/A _724_/B VGND VGND VPWR VPWR _609_/A sky130_fd_sc_hd__or2_2
XFILLER_32_211 VGND VGND VPWR VPWR sky130_fd_sc_hd__decap_3
X_539_ _539_/A _539_/B VGND VGND VPWR VPWR _539_/X sky130_fd_sc_hd__or2_2
XFILLER_4_93 VGND VGND VPWR VPWR sky130_fd_sc_hd__decap_3
XFILLER_3_6 VGND VGND VPWR VPWR sky130_fd_sc_hd__decap_3
XFILLER_0_29 VGND VGND VPWR VPWR sky130_fd_sc_hd__fill_2
XFILLER_9_49 VGND VGND VPWR VPWR sky130_fd_sc_hd__decap_3
XFILLER_1_181 VGND VGND VPWR VPWR sky130_fd_sc_hd__decap_3
XFILLER_20_203 VGND VGND VPWR VPWR sky130_fd_sc_hd__fill_1
XFILLER_1_3 VGND VGND VPWR VPWR sky130_fd_sc_hd__decap_3
XFILLER_34_3 VGND VGND VPWR VPWR sky130_fd_sc_hd__fill_1
XFILLER_20_37 VGND VGND VPWR VPWR sky130_fd_sc_hd__decap_3
XFILLER_29_57 VGND VGND VPWR VPWR sky130_fd_sc_hd__decap_3
XFILLER_28_111 VGND VGND VPWR VPWR sky130_fd_sc_hd__decap_3
XFILLER_19_111 VGND VGND VPWR VPWR sky130_fd_sc_hd__fill_1
XFILLER_19_122 VGND VGND VPWR VPWR sky130_fd_sc_hd__decap_3
XFILLER_19_188 VGND VGND VPWR VPWR sky130_fd_sc_hd__fill_1
XFILLER_15_26 VGND VGND VPWR VPWR sky130_fd_sc_hd__decap_3
XFILLER_25_169 VGND VGND VPWR VPWR sky130_fd_sc_hd__fill_1
XFILLER_25_147 VGND VGND VPWR VPWR sky130_fd_sc_hd__decap_3
XFILLER_25_125 VGND VGND VPWR VPWR sky130_fd_sc_hd__decap_3
XFILLER_33_191 VGND VGND VPWR VPWR sky130_fd_sc_hd__decap_3
XFILLER_31_47 VGND VGND VPWR VPWR sky130_fd_sc_hd__decap_3
Xoutput69 _633_/Y VGND VGND VPWR VPWR S[12] sky130_fd_sc_hd__buf_6
XFILLER_16_114 VGND VGND VPWR VPWR sky130_fd_sc_hd__decap_3
X_572_ _569_/A _568_/A _568_/B _570_/A VGND VGND VPWR VPWR _572_/X sky130_fd_sc_hd__o22a_2
X_641_ _728_/B _668_/Y VGND VGND VPWR VPWR _641_/X sky130_fd_sc_hd__or2_2
X_710_ _723_/B _724_/B VGND VGND VPWR VPWR _710_/Y sky130_fd_sc_hd__nand2_2
XFILLER_16_169 VGND VGND VPWR VPWR sky130_fd_sc_hd__fill_2
XFILLER_31_128 VGND VGND VPWR VPWR sky130_fd_sc_hd__fill_1
XTAP_TAPCELL_ROW_32_189 VGND VPWR sky130_fd_sc_hd__tapvpwrvgnd_1
XFILLER_30_183 VGND VGND VPWR VPWR sky130_fd_sc_hd__decap_3
XFILLER_30_150 VGND VGND VPWR VPWR sky130_fd_sc_hd__decap_3
XFILLER_22_128 VGND VGND VPWR VPWR sky130_fd_sc_hd__decap_3
XFILLER_7_60 VGND VGND VPWR VPWR sky130_fd_sc_hd__decap_3
XFILLER_13_128 VGND VGND VPWR VPWR sky130_fd_sc_hd__decap_3
XFILLER_26_69 VGND VGND VPWR VPWR sky130_fd_sc_hd__fill_1
XFILLER_21_150 VGND VGND VPWR VPWR sky130_fd_sc_hd__decap_3
XFILLER_3_18 VGND VGND VPWR VPWR sky130_fd_sc_hd__fill_2
X_555_ _554_/B _661_/B VGND VGND VPWR VPWR _556_/B sky130_fd_sc_hd__and2b_2
X_624_ _624_/A _624_/B _623_/X VGND VGND VPWR VPWR _625_/B sky130_fd_sc_hd__or3b_4
XFILLER_36_209 VGND VGND VPWR VPWR sky130_fd_sc_hd__decap_3
XFILLER_12_150 VGND VGND VPWR VPWR sky130_fd_sc_hd__decap_3
X_486_ _494_/C _486_/B VGND VGND VPWR VPWR _486_/Y sky130_fd_sc_hd__xnor2_2
XFILLER_8_121 VGND VGND VPWR VPWR sky130_fd_sc_hd__decap_3
XFILLER_8_165 VGND VGND VPWR VPWR sky130_fd_sc_hd__decap_3
XPHY_EDGE_ROW_19_Left_56 VGND VGND VPWR VPWR sky130_fd_sc_hd__decap_3
XFILLER_10_109 VGND VGND VPWR VPWR sky130_fd_sc_hd__decap_3
XTAP_TAPCELL_ROW_20_148 VGND VPWR sky130_fd_sc_hd__tapvpwrvgnd_1
XFILLER_5_146 VGND VGND VPWR VPWR sky130_fd_sc_hd__decap_3
XFILLER_5_113 VGND VGND VPWR VPWR sky130_fd_sc_hd__decap_3
X_538_ _539_/A _539_/B VGND VGND VPWR VPWR _538_/Y sky130_fd_sc_hd__nand2_2
X_607_ _722_/Y _720_/X _606_/X _605_/X VGND VGND VPWR VPWR _610_/B sky130_fd_sc_hd__o211ai_2
XFILLER_27_90 VGND VGND VPWR VPWR sky130_fd_sc_hd__decap_3
X_469_ _458_/B _448_/X _468_/X _471_/A VGND VGND VPWR VPWR _469_/X sky130_fd_sc_hd__o22a_2
XFILLER_4_83 VGND VGND VPWR VPWR sky130_fd_sc_hd__fill_1
XFILLER_4_50 VGND VGND VPWR VPWR sky130_fd_sc_hd__decap_3
XFILLER_23_48 VGND VGND VPWR VPWR sky130_fd_sc_hd__fill_2
XFILLER_2_116 VGND VGND VPWR VPWR sky130_fd_sc_hd__fill_1
XFILLER_14_201 VGND VGND VPWR VPWR sky130_fd_sc_hd__decap_3
XFILLER_9_39 VGND VGND VPWR VPWR sky130_fd_sc_hd__fill_2
XFILLER_1_193 VGND VGND VPWR VPWR sky130_fd_sc_hd__decap_3
XFILLER_18_26 VGND VGND VPWR VPWR sky130_fd_sc_hd__fill_2
XFILLER_18_59 VGND VGND VPWR VPWR sky130_fd_sc_hd__decap_3
XFILLER_27_3 VGND VGND VPWR VPWR sky130_fd_sc_hd__fill_1
XFILLER_20_27 VGND VGND VPWR VPWR sky130_fd_sc_hd__fill_1
XFILLER_29_69 VGND VGND VPWR VPWR sky130_fd_sc_hd__decap_3
XFILLER_28_178 VGND VGND VPWR VPWR sky130_fd_sc_hd__decap_3
XPHY_EDGE_ROW_7_Left_44 VGND VGND VPWR VPWR sky130_fd_sc_hd__decap_3
XFILLER_19_134 VGND VGND VPWR VPWR sky130_fd_sc_hd__decap_3
XFILLER_0_203 VGND VGND VPWR VPWR sky130_fd_sc_hd__decap_3
XPHY_EDGE_ROW_1_Right_1 VGND VGND VPWR VPWR sky130_fd_sc_hd__decap_3
XFILLER_16_126 VGND VGND VPWR VPWR sky130_fd_sc_hd__fill_1
XFILLER_16_148 VGND VGND VPWR VPWR sky130_fd_sc_hd__decap_3
X_571_ _571_/A _571_/B VGND VGND VPWR VPWR _571_/Y sky130_fd_sc_hd__xnor2_2
X_640_ _730_/C _640_/B VGND VGND VPWR VPWR _640_/Y sky130_fd_sc_hd__xnor2_2
XFILLER_31_107 VGND VGND VPWR VPWR sky130_fd_sc_hd__fill_2
XFILLER_21_70 VGND VGND VPWR VPWR sky130_fd_sc_hd__decap_3
XFILLER_22_107 VGND VGND VPWR VPWR sky130_fd_sc_hd__decap_3
XFILLER_7_72 VGND VGND VPWR VPWR sky130_fd_sc_hd__decap_3
XFILLER_7_94 VGND VGND VPWR VPWR sky130_fd_sc_hd__fill_1
XFILLER_21_162 VGND VGND VPWR VPWR sky130_fd_sc_hd__fill_1
XFILLER_16_70 VGND VGND VPWR VPWR sky130_fd_sc_hd__decap_3
X_554_ _661_/B _554_/B VGND VGND VPWR VPWR _556_/A sky130_fd_sc_hd__and2b_2
X_623_ _621_/X _622_/Y _623_/S VGND VGND VPWR VPWR _623_/X sky130_fd_sc_hd__mux2_2
X_485_ _481_/X _482_/X _483_/X _484_/X VGND VGND VPWR VPWR _486_/B sky130_fd_sc_hd__o2bb2a_4
XFILLER_8_144 VGND VGND VPWR VPWR sky130_fd_sc_hd__decap_3
XFILLER_8_100 VGND VGND VPWR VPWR sky130_fd_sc_hd__fill_2
XFILLER_35_210 VGND VGND VPWR VPWR sky130_fd_sc_hd__decap_3
XFILLER_12_39 VGND VGND VPWR VPWR sky130_fd_sc_hd__decap_3
XTAP_TAPCELL_ROW_20_149 VGND VPWR sky130_fd_sc_hd__tapvpwrvgnd_1
XTAP_TAPCELL_ROW_11_116 VGND VPWR sky130_fd_sc_hd__tapvpwrvgnd_1
XPHY_EDGE_ROW_36_Left_73 VGND VGND VPWR VPWR sky130_fd_sc_hd__decap_3
XFILLER_5_169 VGND VGND VPWR VPWR sky130_fd_sc_hd__decap_3
XPHY_EDGE_ROW_20_Left_57 VGND VGND VPWR VPWR sky130_fd_sc_hd__decap_3
X_537_ _519_/C _519_/B _519_/A _532_/B VGND VGND VPWR VPWR _537_/X sky130_fd_sc_hd__a31o_4
X_606_ _722_/Y _720_/X _603_/B VGND VGND VPWR VPWR _606_/X sky130_fd_sc_hd__a21o_2
X_468_ _468_/A _468_/B VGND VGND VPWR VPWR _468_/X sky130_fd_sc_hd__xor2_2
X_399_ _401_/B _399_/B VGND VGND VPWR VPWR _399_/Y sky130_fd_sc_hd__xnor2_2
XFILLER_4_180 VGND VGND VPWR VPWR sky130_fd_sc_hd__fill_1
XFILLER_23_16 VGND VGND VPWR VPWR sky130_fd_sc_hd__fill_2
XFILLER_2_139 VGND VGND VPWR VPWR sky130_fd_sc_hd__fill_1
XTAP_TAPCELL_ROW_0_74 VGND VPWR sky130_fd_sc_hd__tapvpwrvgnd_1
XFILLER_18_38 VGND VGND VPWR VPWR sky130_fd_sc_hd__decap_3
XFILLER_34_26 VGND VGND VPWR VPWR sky130_fd_sc_hd__fill_2
XPHY_EDGE_ROW_23_Left_60 VGND VGND VPWR VPWR sky130_fd_sc_hd__decap_3
XFILLER_29_37 VGND VGND VPWR VPWR sky130_fd_sc_hd__fill_1
XFILLER_10_61 VGND VGND VPWR VPWR sky130_fd_sc_hd__decap_3
XFILLER_10_94 VGND VGND VPWR VPWR sky130_fd_sc_hd__decap_3
XFILLER_19_102 VGND VGND VPWR VPWR sky130_fd_sc_hd__decap_3
XFILLER_19_113 VGND VGND VPWR VPWR sky130_fd_sc_hd__decap_3
XFILLER_19_70 VGND VGND VPWR VPWR sky130_fd_sc_hd__decap_3
XFILLER_33_182 VGND VGND VPWR VPWR sky130_fd_sc_hd__decap_3
XFILLER_25_116 VGND VGND VPWR VPWR sky130_fd_sc_hd__decap_3
XFILLER_31_38 VGND VGND VPWR VPWR sky130_fd_sc_hd__decap_3
XFILLER_0_215 VGND VGND VPWR VPWR sky130_fd_sc_hd__fill_2
XFILLER_16_105 VGND VGND VPWR VPWR sky130_fd_sc_hd__decap_3
X_570_ _570_/A _570_/B VGND VGND VPWR VPWR _571_/B sky130_fd_sc_hd__nor2_2
XFILLER_31_119 VGND VGND VPWR VPWR sky130_fd_sc_hd__decap_3
XFILLER_24_193 VGND VGND VPWR VPWR sky130_fd_sc_hd__decap_3
XFILLER_21_60 VGND VGND VPWR VPWR sky130_fd_sc_hd__fill_2
X_699_ _709_/B _724_/A VGND VGND VPWR VPWR _707_/A sky130_fd_sc_hd__and2b_2
XFILLER_22_119 VGND VGND VPWR VPWR sky130_fd_sc_hd__decap_3
XFILLER_7_51 VGND VGND VPWR VPWR sky130_fd_sc_hd__decap_3
XFILLER_30_141 VGND VGND VPWR VPWR sky130_fd_sc_hd__decap_3
XPHY_EDGE_ROW_15_Right_15 VGND VGND VPWR VPWR sky130_fd_sc_hd__decap_3
XPHY_EDGE_ROW_24_Right_24 VGND VGND VPWR VPWR sky130_fd_sc_hd__decap_3
XFILLER_26_27 VGND VGND VPWR VPWR sky130_fd_sc_hd__fill_1
XFILLER_13_108 VGND VGND VPWR VPWR sky130_fd_sc_hd__decap_3
XFILLER_13_119 VGND VGND VPWR VPWR sky130_fd_sc_hd__decap_3
XTAP_TAPCELL_ROW_23_158 VGND VPWR sky130_fd_sc_hd__tapvpwrvgnd_1
XPHY_EDGE_ROW_33_Right_33 VGND VGND VPWR VPWR sky130_fd_sc_hd__decap_3
X_622_ _622_/A _734_/B VGND VGND VPWR VPWR _622_/Y sky130_fd_sc_hd__nand2_2
XFILLER_16_82 VGND VGND VPWR VPWR sky130_fd_sc_hd__fill_2
X_553_ _657_/B _553_/B VGND VGND VPWR VPWR _553_/Y sky130_fd_sc_hd__xnor2_2
X_484_ _477_/B _479_/A _413_/A VGND VGND VPWR VPWR _484_/X sky130_fd_sc_hd__a21o_2
XFILLER_12_130 VGND VGND VPWR VPWR sky130_fd_sc_hd__fill_1
XFILLER_32_92 VGND VGND VPWR VPWR sky130_fd_sc_hd__decap_3
XFILLER_32_81 VGND VGND VPWR VPWR sky130_fd_sc_hd__decap_3
XTAP_TAPCELL_ROW_11_117 VGND VPWR sky130_fd_sc_hd__tapvpwrvgnd_1
XFILLER_5_137 VGND VGND VPWR VPWR sky130_fd_sc_hd__decap_3
X_605_ _704_/X _707_/C _588_/B VGND VGND VPWR VPWR _605_/X sky130_fd_sc_hd__a21bo_2
XFILLER_27_81 VGND VGND VPWR VPWR sky130_fd_sc_hd__decap_3
X_536_ _536_/A _536_/B VGND VGND VPWR VPWR _536_/Y sky130_fd_sc_hd__xnor2_4
X_467_ _440_/X _463_/X _464_/X VGND VGND VPWR VPWR _467_/X sky130_fd_sc_hd__a21bo_2
X_398_ _586_/B _423_/C VGND VGND VPWR VPWR _399_/B sky130_fd_sc_hd__xnor2_2
XFILLER_32_214 VGND VGND VPWR VPWR sky130_fd_sc_hd__decap_3
XFILLER_4_96 VGND VGND VPWR VPWR sky130_fd_sc_hd__fill_1
XFILLER_4_85 VGND VGND VPWR VPWR sky130_fd_sc_hd__fill_1
XFILLER_4_74 VGND VGND VPWR VPWR sky130_fd_sc_hd__decap_3
XFILLER_4_41 VGND VGND VPWR VPWR sky130_fd_sc_hd__decap_3
XFILLER_3_9 VGND VGND VPWR VPWR sky130_fd_sc_hd__decap_3
XFILLER_14_214 VGND VGND VPWR VPWR sky130_fd_sc_hd__decap_3
XTAP_TAPCELL_ROW_0_75 VGND VPWR sky130_fd_sc_hd__tapvpwrvgnd_1
XFILLER_1_184 VGND VGND VPWR VPWR sky130_fd_sc_hd__decap_3
X_519_ _519_/A _519_/B _519_/C VGND VGND VPWR VPWR _533_/C sky130_fd_sc_hd__nand3_2
XFILLER_1_6 VGND VGND VPWR VPWR sky130_fd_sc_hd__decap_3
XFILLER_24_60 VGND VGND VPWR VPWR sky130_fd_sc_hd__decap_3
XFILLER_29_49 VGND VGND VPWR VPWR sky130_fd_sc_hd__fill_2
XFILLER_28_158 VGND VGND VPWR VPWR sky130_fd_sc_hd__fill_1
XFILLER_28_136 VGND VGND VPWR VPWR sky130_fd_sc_hd__decap_3
XFILLER_19_125 VGND VGND VPWR VPWR sky130_fd_sc_hd__decap_3
XFILLER_19_82 VGND VGND VPWR VPWR sky130_fd_sc_hd__fill_2
XFILLER_34_139 VGND VGND VPWR VPWR sky130_fd_sc_hd__fill_1
XFILLER_19_93 VGND VGND VPWR VPWR sky130_fd_sc_hd__decap_3
XFILLER_25_128 VGND VGND VPWR VPWR sky130_fd_sc_hd__decap_3
XFILLER_15_29 VGND VGND VPWR VPWR sky130_fd_sc_hd__decap_3
XFILLER_18_191 VGND VGND VPWR VPWR sky130_fd_sc_hd__decap_3
XFILLER_33_194 VGND VGND VPWR VPWR sky130_fd_sc_hd__fill_1
XFILLER_33_150 VGND VGND VPWR VPWR sky130_fd_sc_hd__decap_3
XFILLER_31_17 VGND VGND VPWR VPWR sky130_fd_sc_hd__decap_3
XFILLER_16_117 VGND VGND VPWR VPWR sky130_fd_sc_hd__decap_3
XFILLER_24_150 VGND VGND VPWR VPWR sky130_fd_sc_hd__fill_2
X_698_ _732_/S _698_/B _698_/C _698_/D VGND VGND VPWR VPWR _698_/X sky130_fd_sc_hd__and4_2
XFILLER_30_153 VGND VGND VPWR VPWR sky130_fd_sc_hd__decap_3
XFILLER_30_120 VGND VGND VPWR VPWR sky130_fd_sc_hd__decap_3
XFILLER_7_85 VGND VGND VPWR VPWR sky130_fd_sc_hd__decap_3
XFILLER_7_63 VGND VGND VPWR VPWR sky130_fd_sc_hd__decap_3
XFILLER_30_197 VGND VGND VPWR VPWR sky130_fd_sc_hd__decap_3
XFILLER_30_186 VGND VGND VPWR VPWR sky130_fd_sc_hd__fill_1
XTAP_TAPCELL_ROW_23_159 VGND VPWR sky130_fd_sc_hd__tapvpwrvgnd_1
XFILLER_21_153 VGND VGND VPWR VPWR sky130_fd_sc_hd__decap_3
XFILLER_21_131 VGND VGND VPWR VPWR sky130_fd_sc_hd__decap_3
X_621_ _622_/A _734_/B VGND VGND VPWR VPWR _621_/X sky130_fd_sc_hd__or2_2
XFILLER_12_153 VGND VGND VPWR VPWR sky130_fd_sc_hd__decap_3
X_552_ _661_/A _552_/B VGND VGND VPWR VPWR _553_/B sky130_fd_sc_hd__xnor2_2
X_483_ _477_/B _479_/A _477_/A VGND VGND VPWR VPWR _483_/X sky130_fd_sc_hd__o21a_2
XTAP_TAPCELL_ROW_14_126 VGND VPWR sky130_fd_sc_hd__tapvpwrvgnd_1
XFILLER_12_197 VGND VGND VPWR VPWR sky130_fd_sc_hd__fill_2
XFILLER_8_168 VGND VGND VPWR VPWR sky130_fd_sc_hd__decap_3
XFILLER_8_124 VGND VGND VPWR VPWR sky130_fd_sc_hd__decap_3
XFILLER_32_60 VGND VGND VPWR VPWR sky130_fd_sc_hd__fill_2
XFILLER_35_201 VGND VGND VPWR VPWR sky130_fd_sc_hd__decap_3
XTAP_TAPCELL_ROW_11_118 VGND VPWR sky130_fd_sc_hd__tapvpwrvgnd_1
XFILLER_5_149 VGND VGND VPWR VPWR sky130_fd_sc_hd__decap_3
XFILLER_5_116 VGND VGND VPWR VPWR sky130_fd_sc_hd__decap_3
XFILLER_17_201 VGND VGND VPWR VPWR sky130_fd_sc_hd__decap_3
X_535_ _530_/A _528_/A _532_/X _533_/X _534_/Y VGND VGND VPWR VPWR _536_/B sky130_fd_sc_hd__a2111o_2
X_604_ _604_/A _604_/B VGND VGND VPWR VPWR _604_/Y sky130_fd_sc_hd__xnor2_2
XFILLER_27_93 VGND VGND VPWR VPWR sky130_fd_sc_hd__fill_2
XFILLER_27_60 VGND VGND VPWR VPWR sky130_fd_sc_hd__decap_3
X_466_ _681_/Y _371_/C _371_/B _462_/Y _465_/Y VGND VGND VPWR VPWR _466_/X sky130_fd_sc_hd__a311o_4
X_397_ _397_/A _401_/A VGND VGND VPWR VPWR _423_/C sky130_fd_sc_hd__xnor2_2
XFILLER_4_53 VGND VGND VPWR VPWR sky130_fd_sc_hd__decap_3
XTAP_TAPCELL_ROW_0_76 VGND VPWR sky130_fd_sc_hd__tapvpwrvgnd_1
XFILLER_1_196 VGND VGND VPWR VPWR sky130_fd_sc_hd__decap_3
X_518_ _518_/A _518_/B VGND VGND VPWR VPWR _519_/C sky130_fd_sc_hd__or2_4
X_449_ _427_/A _427_/B _442_/X _448_/X VGND VGND VPWR VPWR _459_/S sky130_fd_sc_hd__a31oi_4
XFILLER_18_29 VGND VGND VPWR VPWR sky130_fd_sc_hd__decap_3
XFILLER_34_39 VGND VGND VPWR VPWR sky130_fd_sc_hd__decap_3
XFILLER_29_17 VGND VGND VPWR VPWR sky130_fd_sc_hd__fill_2
XFILLER_10_52 VGND VGND VPWR VPWR sky130_fd_sc_hd__decap_3
XFILLER_19_137 VGND VGND VPWR VPWR sky130_fd_sc_hd__fill_2
XFILLER_34_129 VGND VGND VPWR VPWR sky130_fd_sc_hd__decap_3
XFILLER_27_181 VGND VGND VPWR VPWR sky130_fd_sc_hd__decap_3
XFILLER_18_170 VGND VGND VPWR VPWR sky130_fd_sc_hd__decap_3
XFILLER_0_206 VGND VGND VPWR VPWR sky130_fd_sc_hd__decap_3
XTAP_TAPCELL_ROW_26_168 VGND VPWR sky130_fd_sc_hd__tapvpwrvgnd_1
XFILLER_21_73 VGND VGND VPWR VPWR sky130_fd_sc_hd__decap_3
X_697_ _568_/B _689_/A _565_/A _568_/A VGND VGND VPWR VPWR _698_/D sky130_fd_sc_hd__a31o_2
XFILLER_30_132 VGND VGND VPWR VPWR sky130_fd_sc_hd__decap_3
XFILLER_7_75 VGND VGND VPWR VPWR sky130_fd_sc_hd__fill_1
XPHY_EDGE_ROW_5_Right_5 VGND VGND VPWR VPWR sky130_fd_sc_hd__decap_3
XFILLER_26_29 VGND VGND VPWR VPWR sky130_fd_sc_hd__decap_3
X_551_ _559_/A _656_/A VGND VGND VPWR VPWR _552_/B sky130_fd_sc_hd__xnor2_2
X_620_ _623_/S _734_/B _734_/A VGND VGND VPWR VPWR _624_/B sky130_fd_sc_hd__and3b_2
XFILLER_12_121 VGND VGND VPWR VPWR sky130_fd_sc_hd__decap_3
XFILLER_16_51 VGND VGND VPWR VPWR sky130_fd_sc_hd__decap_3
XFILLER_16_73 VGND VGND VPWR VPWR sky130_fd_sc_hd__decap_3
X_482_ _477_/B _479_/A _413_/A VGND VGND VPWR VPWR _482_/X sky130_fd_sc_hd__o21a_2
XTAP_TAPCELL_ROW_14_127 VGND VPWR sky130_fd_sc_hd__tapvpwrvgnd_1
XFILLER_8_147 VGND VGND VPWR VPWR sky130_fd_sc_hd__decap_3
XFILLER_35_213 VGND VGND VPWR VPWR sky130_fd_sc_hd__decap_3
Xrebuffer200 _647_/Y VGND VGND VPWR VPWR _650_/B sky130_fd_sc_hd__buf_6
X_534_ _533_/C _533_/D _661_/A _533_/B VGND VGND VPWR VPWR _534_/Y sky130_fd_sc_hd__a211oi_2
X_603_ _722_/Y _603_/B VGND VGND VPWR VPWR _604_/A sky130_fd_sc_hd__xnor2_2
X_465_ _440_/X _463_/X _464_/X VGND VGND VPWR VPWR _465_/Y sky130_fd_sc_hd__a21boi_2
X_396_ _380_/B _389_/X _395_/X VGND VGND VPWR VPWR _401_/B sky130_fd_sc_hd__o21bai_4
XFILLER_4_32 VGND VGND VPWR VPWR sky130_fd_sc_hd__decap_3
XFILLER_4_21 VGND VGND VPWR VPWR sky130_fd_sc_hd__decap_3
XFILLER_13_52 VGND VGND VPWR VPWR sky130_fd_sc_hd__decap_3
XTAP_TAPCELL_ROW_0_77 VGND VPWR sky130_fd_sc_hd__tapvpwrvgnd_1
X_517_ _514_/Y _515_/X _518_/A _518_/B VGND VGND VPWR VPWR _519_/B sky130_fd_sc_hd__a22o_2
X_448_ _437_/B _446_/X _447_/X _445_/A VGND VGND VPWR VPWR _448_/X sky130_fd_sc_hd__a22o_2
X_379_ _379_/A VGND VGND VPWR VPWR _380_/A sky130_fd_sc_hd__inv_2
XFILLER_34_29 VGND VGND VPWR VPWR sky130_fd_sc_hd__decap_3
XFILLER_24_73 VGND VGND VPWR VPWR sky130_fd_sc_hd__fill_2
XFILLER_10_64 VGND VGND VPWR VPWR sky130_fd_sc_hd__fill_1
XFILLER_10_97 VGND VGND VPWR VPWR sky130_fd_sc_hd__decap_3
XFILLER_19_105 VGND VGND VPWR VPWR sky130_fd_sc_hd__decap_3
XFILLER_19_116 VGND VGND VPWR VPWR sky130_fd_sc_hd__decap_3
XFILLER_19_73 VGND VGND VPWR VPWR sky130_fd_sc_hd__decap_3
XTAP_TAPCELL_ROW_6_98 VGND VPWR sky130_fd_sc_hd__tapvpwrvgnd_1
XPHY_EDGE_ROW_27_Left_64 VGND VGND VPWR VPWR sky130_fd_sc_hd__decap_3
XFILLER_18_182 VGND VGND VPWR VPWR sky130_fd_sc_hd__decap_3
XPHY_EDGE_ROW_11_Left_48 VGND VGND VPWR VPWR sky130_fd_sc_hd__decap_3
XFILLER_33_130 VGND VGND VPWR VPWR sky130_fd_sc_hd__decap_3
XFILLER_25_119 VGND VGND VPWR VPWR sky130_fd_sc_hd__decap_3
XFILLER_33_185 VGND VGND VPWR VPWR sky130_fd_sc_hd__decap_3
XFILLER_16_108 VGND VGND VPWR VPWR sky130_fd_sc_hd__decap_3
XTAP_TAPCELL_ROW_26_169 VGND VPWR sky130_fd_sc_hd__tapvpwrvgnd_1
XFILLER_24_141 VGND VGND VPWR VPWR sky130_fd_sc_hd__decap_3
X_696_ _689_/A _565_/A _568_/B VGND VGND VPWR VPWR _698_/C sky130_fd_sc_hd__a21o_2
XFILLER_15_185 VGND VGND VPWR VPWR sky130_fd_sc_hd__fill_2
XFILLER_7_54 VGND VGND VPWR VPWR sky130_fd_sc_hd__fill_2
XFILLER_30_177 VGND VGND VPWR VPWR sky130_fd_sc_hd__decap_3
XFILLER_30_144 VGND VGND VPWR VPWR sky130_fd_sc_hd__decap_3
XFILLER_30_100 VGND VGND VPWR VPWR sky130_fd_sc_hd__fill_2
XFILLER_21_122 VGND VGND VPWR VPWR sky130_fd_sc_hd__decap_3
X_550_ _550_/A _550_/B VGND VGND VPWR VPWR _657_/B sky130_fd_sc_hd__nor2_4
X_481_ _477_/B _479_/A _477_/A VGND VGND VPWR VPWR _481_/X sky130_fd_sc_hd__a21bo_2
XFILLER_12_100 VGND VGND VPWR VPWR sky130_fd_sc_hd__decap_3
XFILLER_12_144 VGND VGND VPWR VPWR sky130_fd_sc_hd__decap_3
XFILLER_16_96 VGND VGND VPWR VPWR sky130_fd_sc_hd__decap_3
XTAP_TAPCELL_ROW_14_128 VGND VPWR sky130_fd_sc_hd__tapvpwrvgnd_1
XPHY_EDGE_ROW_11_Right_11 VGND VGND VPWR VPWR sky130_fd_sc_hd__decap_3
XTAP_TAPCELL_ROW_3_88 VGND VPWR sky130_fd_sc_hd__tapvpwrvgnd_1
XPHY_EDGE_ROW_20_Right_20 VGND VGND VPWR VPWR sky130_fd_sc_hd__decap_3
XFILLER_32_95 VGND VGND VPWR VPWR sky130_fd_sc_hd__decap_3
X_679_ _727_/B _727_/A _726_/A _679_/C1 VGND VGND VPWR VPWR _679_/Y sky130_fd_sc_hd__a211oi_2
XPHY_EDGE_ROW_14_Left_51 VGND VGND VPWR VPWR sky130_fd_sc_hd__decap_3
X_602_ _709_/A _702_/A VGND VGND VPWR VPWR _603_/B sky130_fd_sc_hd__xnor2_2
X_533_ _661_/A _533_/B _533_/C _533_/D VGND VGND VPWR VPWR _533_/X sky130_fd_sc_hd__and4_2
X_464_ _468_/A _464_/B _464_/C _441_/Y VGND VGND VPWR VPWR _464_/X sky130_fd_sc_hd__or4b_4
XFILLER_27_84 VGND VGND VPWR VPWR sky130_fd_sc_hd__decap_3
XFILLER_27_51 VGND VGND VPWR VPWR sky130_fd_sc_hd__decap_3
X_395_ _379_/A _393_/X _394_/X _390_/A VGND VGND VPWR VPWR _395_/X sky130_fd_sc_hd__a22o_2
XFILLER_4_77 VGND VGND VPWR VPWR sky130_fd_sc_hd__decap_3
XFILLER_4_44 VGND VGND VPWR VPWR sky130_fd_sc_hd__decap_3
XFILLER_13_31 VGND VGND VPWR VPWR sky130_fd_sc_hd__decap_3
XTAP_TAPCELL_ROW_0_78 VGND VPWR sky130_fd_sc_hd__tapvpwrvgnd_1
XFILLER_1_165 VGND VGND VPWR VPWR sky130_fd_sc_hd__decap_3
XFILLER_1_187 VGND VGND VPWR VPWR sky130_fd_sc_hd__decap_3
X_516_ _490_/X _477_/B _491_/X _489_/A _505_/A VGND VGND VPWR VPWR _518_/A sky130_fd_sc_hd__a221o_2
X_447_ _521_/A _447_/B VGND VGND VPWR VPWR _447_/X sky130_fd_sc_hd__xor2_2
X_378_ _457_/A VGND VGND VPWR VPWR _586_/B sky130_fd_sc_hd__buf_12
XFILLER_1_9 VGND VGND VPWR VPWR sky130_fd_sc_hd__fill_2
XFILLER_24_85 VGND VGND VPWR VPWR sky130_fd_sc_hd__decap_3
XFILLER_24_63 VGND VGND VPWR VPWR sky130_fd_sc_hd__decap_3
XFILLER_24_41 VGND VGND VPWR VPWR sky130_fd_sc_hd__decap_3
XFILLER_6_202 VGND VGND VPWR VPWR sky130_fd_sc_hd__decap_3
XFILLER_1_89 VGND VGND VPWR VPWR sky130_fd_sc_hd__decap_3
XFILLER_28_139 VGND VGND VPWR VPWR sky130_fd_sc_hd__fill_1
XFILLER_36_161 VGND VGND VPWR VPWR sky130_fd_sc_hd__fill_2
XFILLER_10_32 VGND VGND VPWR VPWR sky130_fd_sc_hd__decap_3
XFILLER_19_128 VGND VGND VPWR VPWR sky130_fd_sc_hd__decap_3
XFILLER_19_96 VGND VGND VPWR VPWR sky130_fd_sc_hd__decap_3
XTAP_TAPCELL_ROW_6_99 VGND VPWR sky130_fd_sc_hd__tapvpwrvgnd_1
XFILLER_18_161 VGND VGND VPWR VPWR sky130_fd_sc_hd__decap_3
XFILLER_18_194 VGND VGND VPWR VPWR sky130_fd_sc_hd__fill_2
XFILLER_33_153 VGND VGND VPWR VPWR sky130_fd_sc_hd__fill_2
XFILLER_24_164 VGND VGND VPWR VPWR sky130_fd_sc_hd__fill_2
XFILLER_24_131 VGND VGND VPWR VPWR sky130_fd_sc_hd__decap_3
XFILLER_15_153 VGND VGND VPWR VPWR sky130_fd_sc_hd__decap_3
X_695_ _695_/A _695_/B VGND VGND VPWR VPWR _698_/B sky130_fd_sc_hd__nor2_2
XTAP_TAPCELL_ROW_17_137 VGND VPWR sky130_fd_sc_hd__tapvpwrvgnd_1
XFILLER_7_88 VGND VGND VPWR VPWR sky130_fd_sc_hd__decap_3
XFILLER_7_66 VGND VGND VPWR VPWR sky130_fd_sc_hd__decap_3
XFILLER_30_123 VGND VGND VPWR VPWR sky130_fd_sc_hd__decap_3
XFILLER_21_156 VGND VGND VPWR VPWR sky130_fd_sc_hd__decap_3
XFILLER_21_134 VGND VGND VPWR VPWR sky130_fd_sc_hd__fill_2
XTAP_TAPCELL_ROW_8_105 VGND VPWR sky130_fd_sc_hd__tapvpwrvgnd_1
X_480_ _491_/B _489_/A VGND VGND VPWR VPWR _494_/C sky130_fd_sc_hd__xnor2_2
XFILLER_12_112 VGND VGND VPWR VPWR sky130_fd_sc_hd__decap_3
XFILLER_12_156 VGND VGND VPWR VPWR sky130_fd_sc_hd__fill_2
XTAP_TAPCELL_ROW_14_129 VGND VPWR sky130_fd_sc_hd__tapvpwrvgnd_1
XTAP_TAPCELL_ROW_3_89 VGND VPWR sky130_fd_sc_hd__tapvpwrvgnd_1
XFILLER_35_204 VGND VGND VPWR VPWR sky130_fd_sc_hd__decap_3
X_678_ _727_/B _677_/Y _726_/A _679_/C1 VGND VGND VPWR VPWR _678_/X sky130_fd_sc_hd__o211a_2
XFILLER_5_119 VGND VGND VPWR VPWR sky130_fd_sc_hd__fill_1
XFILLER_17_204 VGND VGND VPWR VPWR sky130_fd_sc_hd__decap_3
X_601_ _713_/A _592_/B _597_/X _600_/Y VGND VGND VPWR VPWR _604_/B sky130_fd_sc_hd__o211a_2
XFILLER_27_63 VGND VGND VPWR VPWR sky130_fd_sc_hd__decap_3
XFILLER_27_30 VGND VGND VPWR VPWR sky130_fd_sc_hd__decap_3
X_532_ _532_/A _532_/B _533_/C _533_/D VGND VGND VPWR VPWR _532_/X sky130_fd_sc_hd__and4_4
X_463_ _468_/A _464_/B _464_/C VGND VGND VPWR VPWR _463_/X sky130_fd_sc_hd__and3_2
X_394_ _413_/A _394_/B VGND VGND VPWR VPWR _394_/X sky130_fd_sc_hd__xor2_2
XFILLER_4_141 VGND VGND VPWR VPWR sky130_fd_sc_hd__decap_3
XFILLER_4_56 VGND VGND VPWR VPWR sky130_fd_sc_hd__fill_2
XFILLER_4_174 VGND VGND VPWR VPWR sky130_fd_sc_hd__decap_3
XFILLER_4_12 VGND VGND VPWR VPWR sky130_fd_sc_hd__decap_3
XTAP_TAPCELL_ROW_0_79 VGND VPWR sky130_fd_sc_hd__tapvpwrvgnd_1
XFILLER_8_3 VGND VGND VPWR VPWR sky130_fd_sc_hd__fill_1
XFILLER_1_199 VGND VGND VPWR VPWR sky130_fd_sc_hd__decap_3
XFILLER_1_111 VGND VGND VPWR VPWR sky130_fd_sc_hd__fill_1
X_515_ _521_/A _515_/B VGND VGND VPWR VPWR _515_/X sky130_fd_sc_hd__or2_2
X_446_ _667_/X _443_/X _444_/X _445_/X VGND VGND VPWR VPWR _446_/X sky130_fd_sc_hd__a22o_2
X_377_ _561_/A VGND VGND VPWR VPWR _436_/A sky130_fd_sc_hd__buf_6
XFILLER_1_57 VGND VGND VPWR VPWR sky130_fd_sc_hd__fill_1
X_429_ _434_/A _437_/B VGND VGND VPWR VPWR _440_/B sky130_fd_sc_hd__or2b_4
Xinput1 A[0] VGND VGND VPWR VPWR _689_/A sky130_fd_sc_hd__buf_2
XFILLER_10_55 VGND VGND VPWR VPWR sky130_fd_sc_hd__decap_3
XFILLER_19_42 VGND VGND VPWR VPWR sky130_fd_sc_hd__fill_2
XTAP_TAPCELL_ROW_29_179 VGND VPWR sky130_fd_sc_hd__tapvpwrvgnd_1
XFILLER_35_52 VGND VGND VPWR VPWR sky130_fd_sc_hd__decap_3
XFILLER_27_184 VGND VGND VPWR VPWR sky130_fd_sc_hd__fill_2
XFILLER_18_173 VGND VGND VPWR VPWR sky130_fd_sc_hd__decap_3
XFILLER_33_176 VGND VGND VPWR VPWR sky130_fd_sc_hd__decap_3
XFILLER_0_209 VGND VGND VPWR VPWR sky130_fd_sc_hd__decap_3
XFILLER_24_110 VGND VGND VPWR VPWR sky130_fd_sc_hd__decap_3
XFILLER_21_76 VGND VGND VPWR VPWR sky130_fd_sc_hd__decap_3
X_694_ _694_/A _694_/B _694_/C VGND VGND VPWR VPWR _694_/X sky130_fd_sc_hd__and3_2
XFILLER_15_110 VGND VGND VPWR VPWR sky130_fd_sc_hd__fill_2
XTAP_TAPCELL_ROW_17_138 VGND VPWR sky130_fd_sc_hd__tapvpwrvgnd_1
XFILLER_30_135 VGND VGND VPWR VPWR sky130_fd_sc_hd__decap_3
XFILLER_21_179 VGND VGND VPWR VPWR sky130_fd_sc_hd__decap_3
XFILLER_21_113 VGND VGND VPWR VPWR sky130_fd_sc_hd__decap_3
XTAP_TAPCELL_ROW_8_106 VGND VPWR sky130_fd_sc_hd__tapvpwrvgnd_1
XFILLER_12_124 VGND VGND VPWR VPWR sky130_fd_sc_hd__decap_3
XFILLER_16_76 VGND VGND VPWR VPWR sky130_fd_sc_hd__decap_3
XFILLER_12_179 VGND VGND VPWR VPWR sky130_fd_sc_hd__fill_1
XFILLER_8_139 VGND VGND VPWR VPWR sky130_fd_sc_hd__fill_1
XFILLER_32_42 VGND VGND VPWR VPWR sky130_fd_sc_hd__decap_3
X_677_ _727_/A VGND VGND VPWR VPWR _677_/Y sky130_fd_sc_hd__inv_2
XFILLER_35_216 VGND VGND VPWR VPWR sky130_fd_sc_hd__fill_1
XPHY_EDGE_ROW_9_Right_9 VGND VGND VPWR VPWR sky130_fd_sc_hd__decap_3
XFILLER_7_172 VGND VGND VPWR VPWR sky130_fd_sc_hd__decap_3
X_531_ _539_/B _541_/A VGND VGND VPWR VPWR _536_/A sky130_fd_sc_hd__xnor2_2
X_600_ _598_/X _599_/Y _591_/B VGND VGND VPWR VPWR _600_/Y sky130_fd_sc_hd__o21ai_2
X_462_ _387_/A _422_/X _423_/Y VGND VGND VPWR VPWR _462_/Y sky130_fd_sc_hd__a21oi_2
X_393_ _390_/X _391_/X _392_/X _372_/A VGND VGND VPWR VPWR _393_/X sky130_fd_sc_hd__a22o_4
XFILLER_4_24 VGND VGND VPWR VPWR sky130_fd_sc_hd__decap_3
XFILLER_4_35 VGND VGND VPWR VPWR sky130_fd_sc_hd__decap_3
XFILLER_4_197 VGND VGND VPWR VPWR sky130_fd_sc_hd__fill_2
X_729_ _729_/A _729_/B VGND VGND VPWR VPWR _731_/A sky130_fd_sc_hd__xnor2_4
XFILLER_13_55 VGND VGND VPWR VPWR sky130_fd_sc_hd__fill_1
XFILLER_1_178 VGND VGND VPWR VPWR sky130_fd_sc_hd__decap_3
X_514_ _521_/A _515_/B VGND VGND VPWR VPWR _514_/Y sky130_fd_sc_hd__nand2_2
X_445_ _445_/A _447_/B VGND VGND VPWR VPWR _445_/X sky130_fd_sc_hd__or2b_2
X_376_ _732_/S VGND VGND VPWR VPWR _622_/A sky130_fd_sc_hd__buf_4
XFILLER_10_211 VGND VGND VPWR VPWR sky130_fd_sc_hd__decap_3
XFILLER_24_32 VGND VGND VPWR VPWR sky130_fd_sc_hd__decap_3
XFILLER_24_21 VGND VGND VPWR VPWR sky130_fd_sc_hd__decap_3
X_428_ _437_/B _434_/A VGND VGND VPWR VPWR _440_/A sky130_fd_sc_hd__or2b_2
X_359_ _734_/A _734_/B _733_/B VGND VGND VPWR VPWR _359_/X sky130_fd_sc_hd__a21o_2
Xinput2 A[10] VGND VGND VPWR VPWR _733_/B sky130_fd_sc_hd__clkbuf_4
XFILLER_28_108 VGND VGND VPWR VPWR sky130_fd_sc_hd__decap_3
XFILLER_19_108 VGND VGND VPWR VPWR sky130_fd_sc_hd__decap_3
XFILLER_19_119 VGND VGND VPWR VPWR sky130_fd_sc_hd__decap_3
XFILLER_19_76 VGND VGND VPWR VPWR sky130_fd_sc_hd__decap_3
XFILLER_35_97 VGND VGND VPWR VPWR sky130_fd_sc_hd__fill_2
XFILLER_35_31 VGND VGND VPWR VPWR sky130_fd_sc_hd__fill_2
XFILLER_18_141 VGND VGND VPWR VPWR sky130_fd_sc_hd__decap_3
XFILLER_18_185 VGND VGND VPWR VPWR sky130_fd_sc_hd__decap_3
XFILLER_33_188 VGND VGND VPWR VPWR sky130_fd_sc_hd__decap_3
XFILLER_33_133 VGND VGND VPWR VPWR sky130_fd_sc_hd__decap_3
XFILLER_24_144 VGND VGND VPWR VPWR sky130_fd_sc_hd__decap_3
XFILLER_24_122 VGND VGND VPWR VPWR sky130_fd_sc_hd__decap_3
X_693_ _568_/B _689_/X _695_/A _695_/B VGND VGND VPWR VPWR _694_/C sky130_fd_sc_hd__o211a_2
XFILLER_15_122 VGND VGND VPWR VPWR sky130_fd_sc_hd__fill_2
XFILLER_15_166 VGND VGND VPWR VPWR sky130_fd_sc_hd__fill_2
XTAP_TAPCELL_ROW_17_139 VGND VPWR sky130_fd_sc_hd__tapvpwrvgnd_1
XFILLER_30_147 VGND VGND VPWR VPWR sky130_fd_sc_hd__decap_3
XFILLER_7_57 VGND VGND VPWR VPWR sky130_fd_sc_hd__decap_3
XFILLER_16_3 VGND VGND VPWR VPWR sky130_fd_sc_hd__decap_3
XTAP_TAPCELL_ROW_31_186 VGND VPWR sky130_fd_sc_hd__tapvpwrvgnd_1
XFILLER_21_169 VGND VGND VPWR VPWR sky130_fd_sc_hd__fill_1
XFILLER_21_125 VGND VGND VPWR VPWR sky130_fd_sc_hd__decap_3
Xinput60 B[5] VGND VGND VPWR VPWR _701_/A sky130_fd_sc_hd__clkbuf_2
XTAP_TAPCELL_ROW_8_107 VGND VPWR sky130_fd_sc_hd__tapvpwrvgnd_1
XFILLER_12_103 VGND VGND VPWR VPWR sky130_fd_sc_hd__decap_3
XFILLER_12_147 VGND VGND VPWR VPWR sky130_fd_sc_hd__decap_3
XFILLER_16_99 VGND VGND VPWR VPWR sky130_fd_sc_hd__decap_3
XFILLER_8_118 VGND VGND VPWR VPWR sky130_fd_sc_hd__decap_3
X_676_ _650_/A _675_/X _665_/B _727_/A VGND VGND VPWR VPWR _676_/X sky130_fd_sc_hd__o22a_2
XFILLER_7_162 VGND VGND VPWR VPWR sky130_fd_sc_hd__decap_3
X_530_ _530_/A _530_/B VGND VGND VPWR VPWR _530_/Y sky130_fd_sc_hd__xnor2_2
X_461_ _464_/C _461_/B VGND VGND VPWR VPWR _461_/Y sky130_fd_sc_hd__xnor2_2
XFILLER_27_87 VGND VGND VPWR VPWR sky130_fd_sc_hd__decap_3
XFILLER_27_54 VGND VGND VPWR VPWR sky130_fd_sc_hd__fill_2
XFILLER_27_21 VGND VGND VPWR VPWR sky130_fd_sc_hd__decap_3
X_392_ _394_/B _390_/A _413_/A VGND VGND VPWR VPWR _392_/X sky130_fd_sc_hd__o21ba_2
XTAP_TAPCELL_ROW_10_112 VGND VPWR sky130_fd_sc_hd__tapvpwrvgnd_1
XFILLER_4_47 VGND VGND VPWR VPWR sky130_fd_sc_hd__decap_3
XFILLER_4_110 VGND VGND VPWR VPWR sky130_fd_sc_hd__decap_3
X_659_ _436_/A _560_/A _556_/A _658_/X VGND VGND VPWR VPWR _659_/X sky130_fd_sc_hd__o31a_2
X_728_ _728_/A _728_/B VGND VGND VPWR VPWR _731_/C sky130_fd_sc_hd__xnor2_4
XPHY_EDGE_ROW_18_Left_55 VGND VGND VPWR VPWR sky130_fd_sc_hd__decap_3
XFILLER_13_34 VGND VGND VPWR VPWR sky130_fd_sc_hd__decap_3
X_513_ _506_/B _492_/Y _511_/X _512_/X VGND VGND VPWR VPWR _519_/A sky130_fd_sc_hd__a2bb2o_2
X_444_ _434_/A _521_/A VGND VGND VPWR VPWR _444_/X sky130_fd_sc_hd__and2b_2
X_375_ _394_/B _390_/A VGND VGND VPWR VPWR _388_/B sky130_fd_sc_hd__xnor2_2
XFILLER_24_66 VGND VGND VPWR VPWR sky130_fd_sc_hd__fill_2
X_427_ _427_/A _427_/B VGND VGND VPWR VPWR _436_/C sky130_fd_sc_hd__and2_4
X_358_ _734_/A _734_/B _733_/B VGND VGND VPWR VPWR _358_/Y sky130_fd_sc_hd__nand3b_2
XPHY_EDGE_ROW_18_Right_18 VGND VGND VPWR VPWR sky130_fd_sc_hd__decap_3
Xinput3 A[11] VGND VGND VPWR VPWR _736_/B sky130_fd_sc_hd__clkdlybuf4s25_1
XPHY_EDGE_ROW_27_Right_27 VGND VGND VPWR VPWR sky130_fd_sc_hd__decap_3
XFILLER_36_197 VGND VGND VPWR VPWR sky130_fd_sc_hd__decap_3
XFILLER_36_120 VGND VGND VPWR VPWR sky130_fd_sc_hd__decap_3
XFILLER_10_35 VGND VGND VPWR VPWR sky130_fd_sc_hd__fill_1
XPHY_EDGE_ROW_36_Right_36 VGND VGND VPWR VPWR sky130_fd_sc_hd__decap_3
XFILLER_27_131 VGND VGND VPWR VPWR sky130_fd_sc_hd__fill_2
XFILLER_19_99 VGND VGND VPWR VPWR sky130_fd_sc_hd__decap_3
XFILLER_19_55 VGND VGND VPWR VPWR sky130_fd_sc_hd__fill_1
XFILLER_18_131 VGND VGND VPWR VPWR sky130_fd_sc_hd__decap_3
XFILLER_18_164 VGND VGND VPWR VPWR sky130_fd_sc_hd__decap_3
XFILLER_33_101 VGND VGND VPWR VPWR sky130_fd_sc_hd__fill_2
XFILLER_24_134 VGND VGND VPWR VPWR sky130_fd_sc_hd__decap_3
XFILLER_24_101 VGND VGND VPWR VPWR sky130_fd_sc_hd__decap_3
XFILLER_15_101 VGND VGND VPWR VPWR sky130_fd_sc_hd__decap_3
X_692_ _692_/A _692_/B VGND VGND VPWR VPWR _695_/B sky130_fd_sc_hd__xnor2_2
XPHY_EDGE_ROW_6_Left_43 VGND VGND VPWR VPWR sky130_fd_sc_hd__decap_3
XFILLER_30_126 VGND VGND VPWR VPWR sky130_fd_sc_hd__decap_3
XFILLER_7_69 VGND VGND VPWR VPWR sky130_fd_sc_hd__decap_3
Xinput50 B[25] VGND VGND VPWR VPWR _491_/B sky130_fd_sc_hd__dlymetal6s2s_1
Xinput61 B[6] VGND VGND VPWR VPWR _702_/A sky130_fd_sc_hd__dlymetal6s2s_1
XTAP_TAPCELL_ROW_31_187 VGND VPWR sky130_fd_sc_hd__tapvpwrvgnd_1
XFILLER_21_159 VGND VGND VPWR VPWR sky130_fd_sc_hd__decap_3
XTAP_TAPCELL_ROW_8_108 VGND VPWR sky130_fd_sc_hd__tapvpwrvgnd_1
XFILLER_12_115 VGND VGND VPWR VPWR sky130_fd_sc_hd__decap_3
XTAP_TAPCELL_ROW_22_154 VGND VPWR sky130_fd_sc_hd__tapvpwrvgnd_1
XPHY_EDGE_ROW_32_Left_69 VGND VGND VPWR VPWR sky130_fd_sc_hd__decap_3
XPHY_EDGE_ROW_0_Right_0 VGND VGND VPWR VPWR sky130_fd_sc_hd__decap_3
XFILLER_32_11 VGND VGND VPWR VPWR sky130_fd_sc_hd__decap_3
XFILLER_20_181 VGND VGND VPWR VPWR sky130_fd_sc_hd__decap_3
X_675_ _732_/S _670_/Y _671_/X _674_/X VGND VGND VPWR VPWR _675_/X sky130_fd_sc_hd__o31a_2
XFILLER_35_207 VGND VGND VPWR VPWR sky130_fd_sc_hd__decap_3
XFILLER_7_152 VGND VGND VPWR VPWR sky130_fd_sc_hd__fill_1
XFILLER_26_207 VGND VGND VPWR VPWR sky130_fd_sc_hd__fill_1
XFILLER_17_207 VGND VGND VPWR VPWR sky130_fd_sc_hd__fill_1
X_460_ _460_/A _460_/B VGND VGND VPWR VPWR _461_/B sky130_fd_sc_hd__nand2_4
X_391_ _372_/A _391_/B VGND VGND VPWR VPWR _391_/X sky130_fd_sc_hd__and2b_2
XFILLER_27_66 VGND VGND VPWR VPWR sky130_fd_sc_hd__decap_3
XTAP_TAPCELL_ROW_10_113 VGND VPWR sky130_fd_sc_hd__tapvpwrvgnd_1
XFILLER_4_177 VGND VGND VPWR VPWR sky130_fd_sc_hd__decap_3
XFILLER_4_15 VGND VGND VPWR VPWR sky130_fd_sc_hd__decap_3
XFILLER_4_144 VGND VGND VPWR VPWR sky130_fd_sc_hd__decap_3
XFILLER_4_122 VGND VGND VPWR VPWR sky130_fd_sc_hd__decap_3
X_727_ _727_/A _727_/B VGND VGND VPWR VPWR _731_/B sky130_fd_sc_hd__xnor2_4
X_589_ _703_/B _589_/B VGND VGND VPWR VPWR _592_/B sky130_fd_sc_hd__or2_4
X_658_ _661_/B _554_/B _661_/A _559_/A VGND VGND VPWR VPWR _658_/X sky130_fd_sc_hd__a211o_2
XTAP_TAPCELL_ROW_4_91 VGND VPWR sky130_fd_sc_hd__tapvpwrvgnd_1
XFILLER_22_210 VGND VGND VPWR VPWR sky130_fd_sc_hd__decap_3
XFILLER_13_46 VGND VGND VPWR VPWR sky130_fd_sc_hd__decap_3
XFILLER_13_57 VGND VGND VPWR VPWR sky130_fd_sc_hd__fill_1
X_512_ _515_/B _518_/B _521_/A _504_/A VGND VGND VPWR VPWR _512_/X sky130_fd_sc_hd__a211o_2
X_443_ _447_/B _445_/A _434_/A VGND VGND VPWR VPWR _443_/X sky130_fd_sc_hd__o21a_2
X_374_ _380_/B _374_/B VGND VGND VPWR VPWR _374_/Y sky130_fd_sc_hd__xnor2_2
XPHY_EDGE_ROW_35_Left_72 VGND VGND VPWR VPWR sky130_fd_sc_hd__decap_3
XFILLER_0_191 VGND VGND VPWR VPWR sky130_fd_sc_hd__decap_3
X_426_ _420_/C _421_/Y _420_/A _425_/X VGND VGND VPWR VPWR _427_/A sky130_fd_sc_hd__o31a_2
X_357_ _733_/B _356_/X _733_/A VGND VGND VPWR VPWR _357_/Y sky130_fd_sc_hd__o21bai_2
Xinput4 A[12] VGND VGND VPWR VPWR _729_/A sky130_fd_sc_hd__buf_6
XTAP_TAPCELL_ROW_1_81 VGND VPWR sky130_fd_sc_hd__tapvpwrvgnd_1
XFILLER_10_58 VGND VGND VPWR VPWR sky130_fd_sc_hd__decap_3
XFILLER_27_143 VGND VGND VPWR VPWR sky130_fd_sc_hd__fill_2
XFILLER_27_110 VGND VGND VPWR VPWR sky130_fd_sc_hd__fill_2
XFILLER_35_55 VGND VGND VPWR VPWR sky130_fd_sc_hd__fill_1
XFILLER_18_176 VGND VGND VPWR VPWR sky130_fd_sc_hd__decap_3
XFILLER_33_179 VGND VGND VPWR VPWR sky130_fd_sc_hd__decap_3
X_409_ _417_/A VGND VGND VPWR VPWR _409_/Y sky130_fd_sc_hd__inv_2
XTAP_TAPCELL_ROW_34_196 VGND VPWR sky130_fd_sc_hd__tapvpwrvgnd_1
XFILLER_24_179 VGND VGND VPWR VPWR sky130_fd_sc_hd__decap_3
XFILLER_24_113 VGND VGND VPWR VPWR sky130_fd_sc_hd__decap_3
XFILLER_21_57 VGND VGND VPWR VPWR sky130_fd_sc_hd__decap_3
XFILLER_21_46 VGND VGND VPWR VPWR sky130_fd_sc_hd__decap_3
XFILLER_15_113 VGND VGND VPWR VPWR sky130_fd_sc_hd__decap_3
X_691_ _691_/A _691_/B VGND VGND VPWR VPWR _695_/A sky130_fd_sc_hd__xnor2_2
Xmax_cap99 _586_/B VGND VGND VPWR VPWR _648_/A sky130_fd_sc_hd__buf_12
XFILLER_7_37 VGND VGND VPWR VPWR sky130_fd_sc_hd__fill_2
XFILLER_30_138 VGND VGND VPWR VPWR sky130_fd_sc_hd__fill_2
XFILLER_21_116 VGND VGND VPWR VPWR sky130_fd_sc_hd__decap_3
Xinput40 B[16] VGND VGND VPWR VPWR _372_/A sky130_fd_sc_hd__clkdlybuf4s25_1
Xinput51 B[26] VGND VGND VPWR VPWR _504_/A sky130_fd_sc_hd__clkdlybuf4s25_1
Xinput62 B[7] VGND VGND VPWR VPWR _709_/B sky130_fd_sc_hd__clkdlybuf4s25_1
XTAP_TAPCELL_ROW_31_188 VGND VPWR sky130_fd_sc_hd__tapvpwrvgnd_1
XFILLER_12_127 VGND VGND VPWR VPWR sky130_fd_sc_hd__decap_3
XFILLER_12_138 VGND VGND VPWR VPWR sky130_fd_sc_hd__fill_2
XFILLER_16_79 VGND VGND VPWR VPWR sky130_fd_sc_hd__decap_3
XTAP_TAPCELL_ROW_22_155 VGND VPWR sky130_fd_sc_hd__tapvpwrvgnd_1
XFILLER_32_89 VGND VGND VPWR VPWR sky130_fd_sc_hd__decap_3
XFILLER_32_45 VGND VGND VPWR VPWR sky130_fd_sc_hd__decap_3
X_674_ _728_/B _672_/X _673_/X VGND VGND VPWR VPWR _674_/X sky130_fd_sc_hd__a21o_2
XFILLER_11_182 VGND VGND VPWR VPWR sky130_fd_sc_hd__decap_3
XFILLER_7_175 VGND VGND VPWR VPWR sky130_fd_sc_hd__decap_3
XFILLER_21_3 VGND VGND VPWR VPWR sky130_fd_sc_hd__decap_3
XTAP_TAPCELL_ROW_36_203 VGND VPWR sky130_fd_sc_hd__tapvpwrvgnd_1
XFILLER_8_91 VGND VGND VPWR VPWR sky130_fd_sc_hd__decap_3
X_390_ _390_/A _394_/B VGND VGND VPWR VPWR _390_/X sky130_fd_sc_hd__or2b_2
XTAP_TAPCELL_ROW_10_114 VGND VPWR sky130_fd_sc_hd__tapvpwrvgnd_1
XFILLER_4_38 VGND VGND VPWR VPWR sky130_fd_sc_hd__decap_3
XFILLER_4_27 VGND VGND VPWR VPWR sky130_fd_sc_hd__fill_1
X_657_ _657_/A _657_/B VGND VGND VPWR VPWR _657_/Y sky130_fd_sc_hd__nor2_2
X_726_ _726_/A _726_/B VGND VGND VPWR VPWR _731_/D sky130_fd_sc_hd__xnor2_4
X_588_ _703_/B _588_/B VGND VGND VPWR VPWR _591_/B sky130_fd_sc_hd__nand2_4
XFILLER_31_200 VGND VGND VPWR VPWR sky130_fd_sc_hd__decap_3
XTAP_TAPCELL_ROW_4_92 VGND VPWR sky130_fd_sc_hd__tapvpwrvgnd_1
X_511_ _510_/Y _518_/B _667_/X _502_/Y VGND VGND VPWR VPWR _511_/X sky130_fd_sc_hd__a211o_2
X_442_ _440_/X _441_/Y _561_/A VGND VGND VPWR VPWR _442_/X sky130_fd_sc_hd__mux2_2
X_373_ _373_/A _388_/A VGND VGND VPWR VPWR _374_/B sky130_fd_sc_hd__xnor2_2
X_709_ _709_/A _709_/B VGND VGND VPWR VPWR _724_/B sky130_fd_sc_hd__xor2_2
XFILLER_10_214 VGND VGND VPWR VPWR sky130_fd_sc_hd__decap_3
XFILLER_24_57 VGND VGND VPWR VPWR sky130_fd_sc_hd__decap_3
XFILLER_24_35 VGND VGND VPWR VPWR sky130_fd_sc_hd__decap_3
XFILLER_24_24 VGND VGND VPWR VPWR sky130_fd_sc_hd__decap_3
XFILLER_1_39 VGND VGND VPWR VPWR sky130_fd_sc_hd__decap_3
X_425_ _418_/C _418_/B _425_/A3 _424_/X VGND VGND VPWR VPWR _425_/X sky130_fd_sc_hd__a31o_2
X_356_ _734_/A _734_/B VGND VGND VPWR VPWR _356_/X sky130_fd_sc_hd__and2b_2
XTAP_TAPCELL_ROW_1_82 VGND VPWR sky130_fd_sc_hd__tapvpwrvgnd_1
Xinput5 A[13] VGND VGND VPWR VPWR _728_/A sky130_fd_sc_hd__clkbuf_4
XFILLER_27_122 VGND VGND VPWR VPWR sky130_fd_sc_hd__decap_3
XFILLER_19_79 VGND VGND VPWR VPWR sky130_fd_sc_hd__decap_3
XFILLER_2_210 VGND VGND VPWR VPWR sky130_fd_sc_hd__decap_3
XFILLER_18_122 VGND VGND VPWR VPWR sky130_fd_sc_hd__decap_3
XFILLER_18_144 VGND VGND VPWR VPWR sky130_fd_sc_hd__decap_3
XFILLER_18_188 VGND VGND VPWR VPWR sky130_fd_sc_hd__decap_3
X_408_ _630_/A1 _628_/B _630_/B1 VGND VGND VPWR VPWR _420_/B sky130_fd_sc_hd__a21oi_2
XFILLER_24_125 VGND VGND VPWR VPWR sky130_fd_sc_hd__decap_3
XTAP_TAPCELL_ROW_34_197 VGND VPWR sky130_fd_sc_hd__tapvpwrvgnd_1
XFILLER_24_147 VGND VGND VPWR VPWR sky130_fd_sc_hd__decap_3
X_690_ _568_/B _689_/X _568_/A VGND VGND VPWR VPWR _694_/B sky130_fd_sc_hd__a21bo_2
XFILLER_15_169 VGND VGND VPWR VPWR sky130_fd_sc_hd__fill_2
XFILLER_16_6 VGND VGND VPWR VPWR sky130_fd_sc_hd__decap_3
XFILLER_21_128 VGND VGND VPWR VPWR sky130_fd_sc_hd__decap_3
Xinput30 A[7] VGND VGND VPWR VPWR _724_/A sky130_fd_sc_hd__clkdlybuf4s25_1
Xinput41 B[17] VGND VGND VPWR VPWR _394_/B sky130_fd_sc_hd__dlymetal6s4s_1
Xinput52 B[27] VGND VGND VPWR VPWR _515_/B sky130_fd_sc_hd__clkdlybuf4s25_1
Xinput63 B[8] VGND VGND VPWR VPWR _737_/A sky130_fd_sc_hd__dlymetal6s2s_1
XFILLER_12_106 VGND VGND VPWR VPWR sky130_fd_sc_hd__decap_3
XFILLER_16_25 VGND VGND VPWR VPWR sky130_fd_sc_hd__decap_3
XTAP_TAPCELL_ROW_22_156 VGND VPWR sky130_fd_sc_hd__tapvpwrvgnd_1
XFILLER_20_161 VGND VGND VPWR VPWR sky130_fd_sc_hd__fill_1
X_673_ _728_/A _729_/B _729_/A _679_/C1 VGND VGND VPWR VPWR _673_/X sky130_fd_sc_hd__a31o_2
X_742_ _742_/A _742_/B VGND VGND VPWR VPWR _742_/X sky130_fd_sc_hd__or2_4
XTAP_TAPCELL_ROW_13_123 VGND VPWR sky130_fd_sc_hd__tapvpwrvgnd_1
XFILLER_11_172 VGND VGND VPWR VPWR sky130_fd_sc_hd__fill_1
XFILLER_7_165 VGND VGND VPWR VPWR sky130_fd_sc_hd__decap_3
XFILLER_7_143 VGND VGND VPWR VPWR sky130_fd_sc_hd__decap_3
XFILLER_7_110 VGND VGND VPWR VPWR sky130_fd_sc_hd__fill_2
XTAP_TAPCELL_ROW_36_204 VGND VPWR sky130_fd_sc_hd__tapvpwrvgnd_1
XFILLER_8_70 VGND VGND VPWR VPWR sky130_fd_sc_hd__decap_3
XFILLER_27_57 VGND VGND VPWR VPWR sky130_fd_sc_hd__decap_3
XFILLER_27_24 VGND VGND VPWR VPWR sky130_fd_sc_hd__decap_3
XTAP_TAPCELL_ROW_10_115 VGND VPWR sky130_fd_sc_hd__tapvpwrvgnd_1
XFILLER_4_135 VGND VGND VPWR VPWR sky130_fd_sc_hd__decap_3
XFILLER_4_113 VGND VGND VPWR VPWR sky130_fd_sc_hd__decap_3
X_587_ _587_/A _588_/B VGND VGND VPWR VPWR _587_/Y sky130_fd_sc_hd__xnor2_4
X_656_ _656_/A _656_/B _656_/C VGND VGND VPWR VPWR _656_/X sky130_fd_sc_hd__or3_4
X_725_ _722_/Y _712_/X _723_/Y _720_/X _724_/Y VGND VGND VPWR VPWR _725_/X sky130_fd_sc_hd__o221a_4
XTAP_TAPCELL_ROW_4_93 VGND VPWR sky130_fd_sc_hd__tapvpwrvgnd_1
XFILLER_3_190 VGND VGND VPWR VPWR sky130_fd_sc_hd__decap_3
X_510_ _515_/B VGND VGND VPWR VPWR _510_/Y sky130_fd_sc_hd__inv_2
X_441_ _441_/A _441_/B VGND VGND VPWR VPWR _441_/Y sky130_fd_sc_hd__nor2_2
X_372_ _372_/A _379_/A VGND VGND VPWR VPWR _388_/A sky130_fd_sc_hd__xnor2_2
XFILLER_0_182 VGND VGND VPWR VPWR sky130_fd_sc_hd__decap_3
X_639_ _644_/A _635_/X _636_/X _638_/X VGND VGND VPWR VPWR _640_/B sky130_fd_sc_hd__a31o_2
X_708_ _688_/X _694_/X _698_/X _705_/X _707_/Y VGND VGND VPWR VPWR _708_/Y sky130_fd_sc_hd__o32ai_4
XFILLER_5_60 VGND VGND VPWR VPWR sky130_fd_sc_hd__fill_1
X_424_ _387_/A _422_/X _423_/Y VGND VGND VPWR VPWR _424_/X sky130_fd_sc_hd__a21o_2
XFILLER_14_91 VGND VGND VPWR VPWR sky130_fd_sc_hd__decap_3
X_355_ _721_/X _708_/Y _725_/X _742_/X VGND VGND VPWR VPWR _371_/B sky130_fd_sc_hd__a31o_4
XTAP_TAPCELL_ROW_1_83 VGND VPWR sky130_fd_sc_hd__tapvpwrvgnd_1
Xinput6 A[14] VGND VGND VPWR VPWR input6/X sky130_fd_sc_hd__clkbuf_2
XFILLER_10_27 VGND VGND VPWR VPWR sky130_fd_sc_hd__fill_1
XFILLER_10_49 VGND VGND VPWR VPWR sky130_fd_sc_hd__decap_3
XFILLER_19_36 VGND VGND VPWR VPWR sky130_fd_sc_hd__decap_3
XFILLER_27_178 VGND VGND VPWR VPWR sky130_fd_sc_hd__decap_3
XFILLER_27_167 VGND VGND VPWR VPWR sky130_fd_sc_hd__fill_1
XPHY_EDGE_ROW_14_Right_14 VGND VGND VPWR VPWR sky130_fd_sc_hd__decap_3
XPHY_EDGE_ROW_23_Right_23 VGND VGND VPWR VPWR sky130_fd_sc_hd__decap_3
XFILLER_18_134 VGND VGND VPWR VPWR sky130_fd_sc_hd__decap_3
XFILLER_18_167 VGND VGND VPWR VPWR sky130_fd_sc_hd__decap_3
X_407_ _665_/X _676_/X _680_/X VGND VGND VPWR VPWR _420_/C sky130_fd_sc_hd__o21ba_2
XPHY_EDGE_ROW_32_Right_32 VGND VGND VPWR VPWR sky130_fd_sc_hd__decap_3
XFILLER_24_137 VGND VGND VPWR VPWR sky130_fd_sc_hd__decap_3
XFILLER_24_104 VGND VGND VPWR VPWR sky130_fd_sc_hd__decap_3
XTAP_TAPCELL_ROW_34_198 VGND VPWR sky130_fd_sc_hd__tapvpwrvgnd_1
XFILLER_32_181 VGND VGND VPWR VPWR sky130_fd_sc_hd__decap_3
XFILLER_15_104 VGND VGND VPWR VPWR sky130_fd_sc_hd__decap_3
XTAP_TAPCELL_ROW_25_165 VGND VPWR sky130_fd_sc_hd__tapvpwrvgnd_1
XFILLER_30_129 VGND VGND VPWR VPWR sky130_fd_sc_hd__decap_3
XFILLER_23_192 VGND VGND VPWR VPWR sky130_fd_sc_hd__decap_3
XFILLER_14_170 VGND VGND VPWR VPWR sky130_fd_sc_hd__decap_3
Xinput20 A[27] VGND VGND VPWR VPWR _518_/B sky130_fd_sc_hd__clkdlybuf4s25_1
Xinput31 A[8] VGND VGND VPWR VPWR _737_/B sky130_fd_sc_hd__clkdlybuf4s25_1
Xinput42 B[18] VGND VGND VPWR VPWR _397_/A sky130_fd_sc_hd__clkdlybuf4s25_1
Xinput64 B[9] VGND VGND VPWR VPWR _734_/A sky130_fd_sc_hd__buf_6
Xinput53 B[28] VGND VGND VPWR VPWR _532_/A sky130_fd_sc_hd__clkdlybuf4s25_1
XFILLER_12_118 VGND VGND VPWR VPWR sky130_fd_sc_hd__decap_3
XFILLER_16_48 VGND VGND VPWR VPWR sky130_fd_sc_hd__decap_3
XTAP_TAPCELL_ROW_22_157 VGND VPWR sky130_fd_sc_hd__tapvpwrvgnd_1
XFILLER_32_14 VGND VGND VPWR VPWR sky130_fd_sc_hd__decap_3
X_672_ _729_/B _729_/A _728_/A VGND VGND VPWR VPWR _672_/X sky130_fd_sc_hd__a21o_2
X_741_ _735_/X _738_/Y _739_/X _740_/Y VGND VGND VPWR VPWR _742_/B sky130_fd_sc_hd__o2bb2a_4
XTAP_TAPCELL_ROW_13_124 VGND VPWR sky130_fd_sc_hd__tapvpwrvgnd_1
XTAP_TAPCELL_ROW_36_205 VGND VPWR sky130_fd_sc_hd__tapvpwrvgnd_1
XFILLER_8_82 VGND VGND VPWR VPWR sky130_fd_sc_hd__fill_2
XPHY_EDGE_ROW_4_Right_4 VGND VGND VPWR VPWR sky130_fd_sc_hd__decap_3
XFILLER_4_29 VGND VGND VPWR VPWR sky130_fd_sc_hd__decap_3
XFILLER_4_18 VGND VGND VPWR VPWR sky130_fd_sc_hd__decap_3
XFILLER_4_125 VGND VGND VPWR VPWR sky130_fd_sc_hd__decap_3
X_724_ _724_/A _724_/B VGND VGND VPWR VPWR _724_/Y sky130_fd_sc_hd__nand2_2
X_586_ _706_/D _586_/B VGND VGND VPWR VPWR _587_/A sky130_fd_sc_hd__xnor2_4
X_655_ _730_/B _655_/B VGND VGND VPWR VPWR _655_/Y sky130_fd_sc_hd__xnor2_2
XTAP_TAPCELL_ROW_4_94 VGND VPWR sky130_fd_sc_hd__tapvpwrvgnd_1
XFILLER_22_213 VGND VGND VPWR VPWR sky130_fd_sc_hd__decap_3
XFILLER_13_49 VGND VGND VPWR VPWR sky130_fd_sc_hd__decap_3
X_440_ _440_/A _440_/B _441_/B VGND VGND VPWR VPWR _440_/X sky130_fd_sc_hd__and3_2
X_371_ _681_/Y _371_/B _371_/C VGND VGND VPWR VPWR _380_/B sky130_fd_sc_hd__and3_2
XFILLER_0_194 VGND VGND VPWR VPWR sky130_fd_sc_hd__fill_2
X_707_ _707_/A _707_/B _707_/C VGND VGND VPWR VPWR _707_/Y sky130_fd_sc_hd__nor3_2
X_569_ _569_/A _689_/A VGND VGND VPWR VPWR _570_/B sky130_fd_sc_hd__xnor2_2
X_638_ _729_/A _633_/A _637_/X _436_/A VGND VGND VPWR VPWR _638_/X sky130_fd_sc_hd__o211a_2
XFILLER_5_72 VGND VGND VPWR VPWR sky130_fd_sc_hd__decap_3
XFILLER_5_50 VGND VGND VPWR VPWR sky130_fd_sc_hd__decap_3
XFILLER_6_209 VGND VGND VPWR VPWR sky130_fd_sc_hd__fill_2
X_423_ _423_/A _423_/B _423_/C _423_/D VGND VGND VPWR VPWR _423_/Y sky130_fd_sc_hd__nor4_2
XFILLER_30_91 VGND VGND VPWR VPWR sky130_fd_sc_hd__decap_3
Xinput7 A[15] VGND VGND VPWR VPWR _727_/A sky130_fd_sc_hd__buf_4
XFILLER_27_113 VGND VGND VPWR VPWR sky130_fd_sc_hd__decap_3
XFILLER_35_69 VGND VGND VPWR VPWR sky130_fd_sc_hd__fill_2
XFILLER_4_3 VGND VGND VPWR VPWR sky130_fd_sc_hd__decap_3
XFILLER_18_113 VGND VGND VPWR VPWR sky130_fd_sc_hd__decap_3
XFILLER_18_179 VGND VGND VPWR VPWR sky130_fd_sc_hd__decap_3
X_406_ _423_/D _406_/B VGND VGND VPWR VPWR _406_/Y sky130_fd_sc_hd__xnor2_2
XFILLER_24_116 VGND VGND VPWR VPWR sky130_fd_sc_hd__decap_3
XTAP_TAPCELL_ROW_34_199 VGND VPWR sky130_fd_sc_hd__tapvpwrvgnd_1
XFILLER_15_116 VGND VGND VPWR VPWR sky130_fd_sc_hd__decap_3
XTAP_TAPCELL_ROW_25_166 VGND VPWR sky130_fd_sc_hd__tapvpwrvgnd_1
XFILLER_11_60 VGND VGND VPWR VPWR sky130_fd_sc_hd__decap_3
XTAP_TAPCELL_ROW_16_133 VGND VPWR sky130_fd_sc_hd__tapvpwrvgnd_1
XFILLER_14_193 VGND VGND VPWR VPWR sky130_fd_sc_hd__decap_3
Xinput10 A[18] VGND VGND VPWR VPWR _401_/A sky130_fd_sc_hd__clkdlybuf4s25_1
Xinput21 A[28] VGND VGND VPWR VPWR _532_/B sky130_fd_sc_hd__clkdlybuf4s25_1
Xinput32 A[9] VGND VGND VPWR VPWR _734_/B sky130_fd_sc_hd__buf_6
Xinput43 B[19] VGND VGND VPWR VPWR _414_/B sky130_fd_sc_hd__clkdlybuf4s25_1
Xinput54 B[29] VGND VGND VPWR VPWR _539_/B sky130_fd_sc_hd__clkdlybuf4s25_1
XPHY_EDGE_ROW_26_Left_63 VGND VGND VPWR VPWR sky130_fd_sc_hd__decap_3
XFILLER_21_119 VGND VGND VPWR VPWR sky130_fd_sc_hd__decap_3
Xinput65 sub VGND VGND VPWR VPWR input65/X sky130_fd_sc_hd__buf_8
XPHY_EDGE_ROW_10_Left_47 VGND VGND VPWR VPWR sky130_fd_sc_hd__decap_3
XFILLER_20_141 VGND VGND VPWR VPWR sky130_fd_sc_hd__decap_3
XFILLER_32_48 VGND VGND VPWR VPWR sky130_fd_sc_hd__decap_3
XFILLER_20_152 VGND VGND VPWR VPWR sky130_fd_sc_hd__decap_3
X_740_ _740_/A _740_/B VGND VGND VPWR VPWR _740_/Y sky130_fd_sc_hd__nand2_2
X_671_ _729_/B _729_/A _728_/A VGND VGND VPWR VPWR _671_/X sky130_fd_sc_hd__and3b_2
XFILLER_11_163 VGND VGND VPWR VPWR sky130_fd_sc_hd__decap_3
XFILLER_11_185 VGND VGND VPWR VPWR sky130_fd_sc_hd__decap_3
XTAP_TAPCELL_ROW_13_125 VGND VPWR sky130_fd_sc_hd__tapvpwrvgnd_1
XFILLER_7_101 VGND VGND VPWR VPWR sky130_fd_sc_hd__decap_3
XFILLER_22_70 VGND VGND VPWR VPWR sky130_fd_sc_hd__fill_2
XFILLER_22_92 VGND VGND VPWR VPWR sky130_fd_sc_hd__fill_2
XFILLER_22_81 VGND VGND VPWR VPWR sky130_fd_sc_hd__decap_3
XTAP_TAPCELL_ROW_36_206 VGND VPWR sky130_fd_sc_hd__tapvpwrvgnd_1
XFILLER_34_200 VGND VGND VPWR VPWR sky130_fd_sc_hd__decap_3
XFILLER_8_94 VGND VGND VPWR VPWR sky130_fd_sc_hd__decap_3
XFILLER_27_48 VGND VGND VPWR VPWR sky130_fd_sc_hd__decap_3
XFILLER_4_104 VGND VGND VPWR VPWR sky130_fd_sc_hd__decap_3
X_654_ _644_/A _651_/Y _650_/Y _652_/X _653_/X VGND VGND VPWR VPWR _655_/B sky130_fd_sc_hd__a32o_2
X_723_ _724_/A _723_/B VGND VGND VPWR VPWR _723_/Y sky130_fd_sc_hd__nand2_2
X_585_ _694_/X _688_/X _698_/X VGND VGND VPWR VPWR _589_/B sky130_fd_sc_hd__or3_4
XFILLER_31_203 VGND VGND VPWR VPWR sky130_fd_sc_hd__decap_3
XFILLER_3_181 VGND VGND VPWR VPWR sky130_fd_sc_hd__decap_3
XPHY_EDGE_ROW_13_Left_50 VGND VGND VPWR VPWR sky130_fd_sc_hd__decap_3
X_370_ _367_/X _628_/B _742_/A _369_/X VGND VGND VPWR VPWR _371_/C sky130_fd_sc_hd__a211o_4
X_637_ _729_/B _635_/X VGND VGND VPWR VPWR _637_/X sky130_fd_sc_hd__or2b_2
X_706_ _709_/A _706_/B _706_/C _706_/D VGND VGND VPWR VPWR _707_/C sky130_fd_sc_hd__nand4_2
XFILLER_28_91 VGND VGND VPWR VPWR sky130_fd_sc_hd__fill_1
XFILLER_28_80 VGND VGND VPWR VPWR sky130_fd_sc_hd__decap_3
X_568_ _568_/A _568_/B VGND VGND VPWR VPWR _571_/A sky130_fd_sc_hd__xnor2_2
X_499_ _586_/B _521_/B VGND VGND VPWR VPWR _500_/B sky130_fd_sc_hd__xnor2_2
XFILLER_5_95 VGND VGND VPWR VPWR sky130_fd_sc_hd__fill_2
XFILLER_24_38 VGND VGND VPWR VPWR sky130_fd_sc_hd__decap_3
XFILLER_24_27 VGND VGND VPWR VPWR sky130_fd_sc_hd__fill_1
X_422_ _423_/A _423_/C _423_/D VGND VGND VPWR VPWR _422_/X sky130_fd_sc_hd__and3_2
XFILLER_14_82 VGND VGND VPWR VPWR sky130_fd_sc_hd__fill_2
Xinput8 A[16] VGND VGND VPWR VPWR _379_/A sky130_fd_sc_hd__clkdlybuf4s25_1
XFILLER_36_147 VGND VGND VPWR VPWR sky130_fd_sc_hd__fill_1
XFILLER_10_29 VGND VGND VPWR VPWR sky130_fd_sc_hd__decap_3
XFILLER_27_125 VGND VGND VPWR VPWR sky130_fd_sc_hd__decap_3
XFILLER_2_213 VGND VGND VPWR VPWR sky130_fd_sc_hd__decap_3
XFILLER_18_125 VGND VGND VPWR VPWR sky130_fd_sc_hd__decap_3
XFILLER_18_147 VGND VGND VPWR VPWR sky130_fd_sc_hd__fill_2
XFILLER_18_158 VGND VGND VPWR VPWR sky130_fd_sc_hd__decap_3
XTAP_TAPCELL_ROW_28_175 VGND VPWR sky130_fd_sc_hd__tapvpwrvgnd_1
X_405_ _413_/A _401_/Y _402_/Y _403_/X _404_/X VGND VGND VPWR VPWR _406_/B sky130_fd_sc_hd__a32o_2
XFILLER_32_172 VGND VGND VPWR VPWR sky130_fd_sc_hd__decap_3
XFILLER_24_128 VGND VGND VPWR VPWR sky130_fd_sc_hd__decap_3
XTAP_TAPCELL_ROW_25_167 VGND VPWR sky130_fd_sc_hd__tapvpwrvgnd_1
XFILLER_11_72 VGND VGND VPWR VPWR sky130_fd_sc_hd__fill_2
XTAP_TAPCELL_ROW_16_134 VGND VPWR sky130_fd_sc_hd__tapvpwrvgnd_1
XFILLER_21_109 VGND VGND VPWR VPWR sky130_fd_sc_hd__decap_3
Xinput11 A[19] VGND VGND VPWR VPWR _417_/A sky130_fd_sc_hd__clkdlybuf4s25_1
Xinput22 A[29] VGND VGND VPWR VPWR _541_/A sky130_fd_sc_hd__clkdlybuf4s25_1
Xinput33 B[0] VGND VGND VPWR VPWR _565_/A sky130_fd_sc_hd__buf_4
Xinput44 B[1] VGND VGND VPWR VPWR _568_/A sky130_fd_sc_hd__clkdlybuf4s25_1
Xinput55 B[2] VGND VGND VPWR VPWR _692_/A sky130_fd_sc_hd__dlymetal6s2s_1
XFILLER_12_109 VGND VGND VPWR VPWR sky130_fd_sc_hd__decap_3
XFILLER_20_120 VGND VGND VPWR VPWR sky130_fd_sc_hd__decap_3
XTAP_TAPCELL_ROW_7_102 VGND VPWR sky130_fd_sc_hd__tapvpwrvgnd_1
X_670_ _668_/Y _669_/X _728_/B VGND VGND VPWR VPWR _670_/Y sky130_fd_sc_hd__a21oi_2
XFILLER_7_146 VGND VGND VPWR VPWR sky130_fd_sc_hd__decap_3
XFILLER_7_135 VGND VGND VPWR VPWR sky130_fd_sc_hd__fill_1
XFILLER_7_113 VGND VGND VPWR VPWR sky130_fd_sc_hd__decap_3
XTAP_TAPCELL_ROW_36_207 VGND VPWR sky130_fd_sc_hd__tapvpwrvgnd_1
XFILLER_34_212 VGND VGND VPWR VPWR sky130_fd_sc_hd__decap_3
XFILLER_8_73 VGND VGND VPWR VPWR sky130_fd_sc_hd__decap_3
XFILLER_27_27 VGND VGND VPWR VPWR sky130_fd_sc_hd__decap_3
XFILLER_25_212 VGND VGND VPWR VPWR sky130_fd_sc_hd__decap_3
XFILLER_4_138 VGND VGND VPWR VPWR sky130_fd_sc_hd__fill_2
XFILLER_4_116 VGND VGND VPWR VPWR sky130_fd_sc_hd__decap_3
X_653_ _650_/A _650_/B _726_/A VGND VGND VPWR VPWR _653_/X sky130_fd_sc_hd__a21o_2
X_722_ _723_/B VGND VGND VPWR VPWR _722_/Y sky130_fd_sc_hd__inv_2
XFILLER_17_60 VGND VGND VPWR VPWR sky130_fd_sc_hd__decap_3
XFILLER_17_93 VGND VGND VPWR VPWR sky130_fd_sc_hd__decap_3
X_584_ _695_/A _584_/B VGND VGND VPWR VPWR _584_/Y sky130_fd_sc_hd__xnor2_2
XFILLER_33_92 VGND VGND VPWR VPWR sky130_fd_sc_hd__decap_3
XFILLER_3_193 VGND VGND VPWR VPWR sky130_fd_sc_hd__decap_3
XFILLER_1_119 VGND VGND VPWR VPWR sky130_fd_sc_hd__fill_1
XFILLER_1_108 VGND VGND VPWR VPWR sky130_fd_sc_hd__decap_3
XFILLER_13_215 VGND VGND VPWR VPWR sky130_fd_sc_hd__fill_2
XFILLER_0_185 VGND VGND VPWR VPWR sky130_fd_sc_hd__decap_3
X_567_ _689_/X _567_/B VGND VGND VPWR VPWR _567_/Y sky130_fd_sc_hd__nand2_2
X_636_ _634_/Y _631_/A _631_/B _729_/B VGND VGND VPWR VPWR _636_/X sky130_fd_sc_hd__a31o_2
X_705_ _707_/A _707_/B _704_/X VGND VGND VPWR VPWR _705_/X sky130_fd_sc_hd__o21ba_4
X_498_ _504_/A _505_/A VGND VGND VPWR VPWR _521_/B sky130_fd_sc_hd__xnor2_2
X_421_ _742_/A VGND VGND VPWR VPWR _421_/Y sky130_fd_sc_hd__bufinv_8
XFILLER_14_94 VGND VGND VPWR VPWR sky130_fd_sc_hd__decap_3
Xinput9 A[17] VGND VGND VPWR VPWR _390_/A sky130_fd_sc_hd__dlygate4sd1_1
X_619_ _734_/B _623_/S _734_/A VGND VGND VPWR VPWR _624_/A sky130_fd_sc_hd__and3b_2
XFILLER_36_137 VGND VGND VPWR VPWR sky130_fd_sc_hd__decap_3
XFILLER_19_39 VGND VGND VPWR VPWR sky130_fd_sc_hd__decap_3
XFILLER_35_192 VGND VGND VPWR VPWR sky130_fd_sc_hd__decap_3
XFILLER_18_137 VGND VGND VPWR VPWR sky130_fd_sc_hd__decap_3
X_404_ _401_/A _401_/B _397_/A VGND VGND VPWR VPWR _404_/X sky130_fd_sc_hd__a21o_2
XTAP_TAPCELL_ROW_28_176 VGND VPWR sky130_fd_sc_hd__tapvpwrvgnd_1
XFILLER_25_82 VGND VGND VPWR VPWR sky130_fd_sc_hd__decap_3
XPHY_EDGE_ROW_10_Right_10 VGND VGND VPWR VPWR sky130_fd_sc_hd__decap_3
XFILLER_2_42 VGND VGND VPWR VPWR sky130_fd_sc_hd__decap_3
XFILLER_24_107 VGND VGND VPWR VPWR sky130_fd_sc_hd__decap_3
XFILLER_32_184 VGND VGND VPWR VPWR sky130_fd_sc_hd__decap_3
XFILLER_15_107 VGND VGND VPWR VPWR sky130_fd_sc_hd__decap_3
XFILLER_23_140 VGND VGND VPWR VPWR sky130_fd_sc_hd__fill_1
XFILLER_23_195 VGND VGND VPWR VPWR sky130_fd_sc_hd__fill_1
XFILLER_11_84 VGND VGND VPWR VPWR sky130_fd_sc_hd__fill_2
XFILLER_14_173 VGND VGND VPWR VPWR sky130_fd_sc_hd__decap_3
XTAP_TAPCELL_ROW_16_135 VGND VPWR sky130_fd_sc_hd__tapvpwrvgnd_1
Xinput12 A[1] VGND VGND VPWR VPWR _568_/B sky130_fd_sc_hd__dlymetal6s4s_1
Xinput23 A[2] VGND VGND VPWR VPWR _692_/B sky130_fd_sc_hd__clkbuf_2
Xinput34 B[10] VGND VGND VPWR VPWR _733_/A sky130_fd_sc_hd__buf_4
Xinput45 B[20] VGND VGND VPWR VPWR _434_/A sky130_fd_sc_hd__dlymetal6s4s_1
Xinput56 B[30] VGND VGND VPWR VPWR _559_/A sky130_fd_sc_hd__clkdlybuf4s25_1
XFILLER_16_29 VGND VGND VPWR VPWR sky130_fd_sc_hd__fill_1
XFILLER_32_39 VGND VGND VPWR VPWR sky130_fd_sc_hd__decap_3
XFILLER_32_17 VGND VGND VPWR VPWR sky130_fd_sc_hd__fill_2
XFILLER_20_132 VGND VGND VPWR VPWR sky130_fd_sc_hd__decap_3
XTAP_TAPCELL_ROW_7_103 VGND VPWR sky130_fd_sc_hd__tapvpwrvgnd_1
XTAP_TAPCELL_ROW_30_182 VGND VPWR sky130_fd_sc_hd__tapvpwrvgnd_1
XFILLER_7_169 VGND VGND VPWR VPWR sky130_fd_sc_hd__decap_3
XFILLER_22_61 VGND VGND VPWR VPWR sky130_fd_sc_hd__decap_3
XTAP_TAPCELL_ROW_36_208 VGND VPWR sky130_fd_sc_hd__tapvpwrvgnd_1
XFILLER_8_85 VGND VGND VPWR VPWR sky130_fd_sc_hd__decap_3
XFILLER_8_41 VGND VGND VPWR VPWR sky130_fd_sc_hd__decap_3
XFILLER_17_72 VGND VGND VPWR VPWR sky130_fd_sc_hd__decap_3
X_583_ _583_/A _583_/B _582_/Y VGND VGND VPWR VPWR _584_/B sky130_fd_sc_hd__or3b_4
X_652_ input6/X _650_/B _436_/A VGND VGND VPWR VPWR _652_/X sky130_fd_sc_hd__o21a_2
X_721_ _710_/Y _712_/X _720_/X VGND VGND VPWR VPWR _721_/X sky130_fd_sc_hd__a21o_2
XFILLER_3_172 VGND VGND VPWR VPWR sky130_fd_sc_hd__decap_3
XPHY_EDGE_ROW_8_Right_8 VGND VGND VPWR VPWR sky130_fd_sc_hd__decap_3
XFILLER_22_216 VGND VGND VPWR VPWR sky130_fd_sc_hd__fill_1
Xmax_cap120 _591_/A VGND VGND VPWR VPWR _716_/B sky130_fd_sc_hd__buf_6
XFILLER_0_197 VGND VGND VPWR VPWR sky130_fd_sc_hd__decap_3
X_704_ _709_/A _706_/B _706_/C _706_/D VGND VGND VPWR VPWR _704_/X sky130_fd_sc_hd__or4_4
X_566_ _689_/A _570_/A VGND VGND VPWR VPWR _567_/B sky130_fd_sc_hd__nand2_2
X_635_ _631_/A _631_/B _634_/Y VGND VGND VPWR VPWR _635_/X sky130_fd_sc_hd__a21o_2
X_497_ _506_/C _497_/B VGND VGND VPWR VPWR _500_/A sky130_fd_sc_hd__nand2_2
XFILLER_5_75 VGND VGND VPWR VPWR sky130_fd_sc_hd__decap_3
XFILLER_5_53 VGND VGND VPWR VPWR sky130_fd_sc_hd__decap_3
XFILLER_24_29 VGND VGND VPWR VPWR sky130_fd_sc_hd__decap_3
X_420_ _420_/A _420_/B _420_/C _631_/A VGND VGND VPWR VPWR _427_/B sky130_fd_sc_hd__or4b_4
XFILLER_14_62 VGND VGND VPWR VPWR sky130_fd_sc_hd__decap_3
XFILLER_14_73 VGND VGND VPWR VPWR sky130_fd_sc_hd__decap_3
XFILLER_30_94 VGND VGND VPWR VPWR sky130_fd_sc_hd__decap_3
XFILLER_30_83 VGND VGND VPWR VPWR sky130_fd_sc_hd__fill_1
X_549_ _476_/B _549_/A2 _548_/Y VGND VGND VPWR VPWR _656_/B sky130_fd_sc_hd__a21oi_4
X_618_ _618_/A _618_/B VGND VGND VPWR VPWR _618_/Y sky130_fd_sc_hd__xnor2_2
XFILLER_35_28 VGND VGND VPWR VPWR sky130_fd_sc_hd__decap_3
XFILLER_27_116 VGND VGND VPWR VPWR sky130_fd_sc_hd__decap_3
XFILLER_4_6 VGND VGND VPWR VPWR sky130_fd_sc_hd__decap_3
XFILLER_18_116 VGND VGND VPWR VPWR sky130_fd_sc_hd__decap_3
X_403_ _401_/A _401_/B _457_/A VGND VGND VPWR VPWR _403_/X sky130_fd_sc_hd__o21a_2
XTAP_TAPCELL_ROW_28_177 VGND VPWR sky130_fd_sc_hd__tapvpwrvgnd_1
XTAP_TAPCELL_ROW_19_144 VGND VPWR sky130_fd_sc_hd__tapvpwrvgnd_1
XFILLER_2_98 VGND VGND VPWR VPWR sky130_fd_sc_hd__fill_2
XFILLER_24_119 VGND VGND VPWR VPWR sky130_fd_sc_hd__decap_3
XFILLER_32_130 VGND VGND VPWR VPWR sky130_fd_sc_hd__fill_2
XFILLER_15_119 VGND VGND VPWR VPWR sky130_fd_sc_hd__decap_3
XFILLER_11_52 VGND VGND VPWR VPWR sky130_fd_sc_hd__decap_3
XFILLER_11_63 VGND VGND VPWR VPWR sky130_fd_sc_hd__decap_3
XFILLER_2_3 VGND VGND VPWR VPWR sky130_fd_sc_hd__decap_3
Xinput13 A[20] VGND VGND VPWR VPWR _437_/B sky130_fd_sc_hd__dlymetal6s2s_1
XTAP_TAPCELL_ROW_16_136 VGND VPWR sky130_fd_sc_hd__tapvpwrvgnd_1
Xinput24 A[30] VGND VGND VPWR VPWR _656_/A sky130_fd_sc_hd__clkdlybuf4s25_1
Xinput35 B[11] VGND VGND VPWR VPWR _736_/A sky130_fd_sc_hd__clkdlybuf4s25_1
Xinput46 B[21] VGND VGND VPWR VPWR _447_/B sky130_fd_sc_hd__clkdlybuf4s25_1
Xinput57 B[31] VGND VGND VPWR VPWR _661_/B sky130_fd_sc_hd__clkdlybuf4s25_1
XFILLER_35_3 VGND VGND VPWR VPWR sky130_fd_sc_hd__decap_3
XTAP_TAPCELL_ROW_30_183 VGND VPWR sky130_fd_sc_hd__tapvpwrvgnd_1
XFILLER_20_155 VGND VGND VPWR VPWR sky130_fd_sc_hd__decap_3
XFILLER_20_144 VGND VGND VPWR VPWR sky130_fd_sc_hd__fill_1
XFILLER_20_111 VGND VGND VPWR VPWR sky130_fd_sc_hd__decap_3
XTAP_TAPCELL_ROW_7_104 VGND VPWR sky130_fd_sc_hd__tapvpwrvgnd_1
XFILLER_11_122 VGND VGND VPWR VPWR sky130_fd_sc_hd__fill_2
XFILLER_7_104 VGND VGND VPWR VPWR sky130_fd_sc_hd__decap_3
XFILLER_11_166 VGND VGND VPWR VPWR sky130_fd_sc_hd__fill_2
XTAP_TAPCELL_ROW_36_209 VGND VPWR sky130_fd_sc_hd__tapvpwrvgnd_1
XFILLER_34_203 VGND VGND VPWR VPWR sky130_fd_sc_hd__decap_3
XFILLER_8_97 VGND VGND VPWR VPWR sky130_fd_sc_hd__decap_3
XFILLER_27_18 VGND VGND VPWR VPWR sky130_fd_sc_hd__decap_3
XFILLER_4_107 VGND VGND VPWR VPWR sky130_fd_sc_hd__decap_3
X_720_ _596_/A _716_/X _715_/X _719_/Y VGND VGND VPWR VPWR _720_/X sky130_fd_sc_hd__a31o_4
X_582_ _622_/A _692_/B _575_/X _581_/X VGND VGND VPWR VPWR _582_/Y sky130_fd_sc_hd__a31oi_2
X_651_ input6/X _650_/B _726_/A VGND VGND VPWR VPWR _651_/Y sky130_fd_sc_hd__o21bai_2
XFILLER_31_206 VGND VGND VPWR VPWR sky130_fd_sc_hd__decap_3
XFILLER_3_184 VGND VGND VPWR VPWR sky130_fd_sc_hd__decap_3
X_634_ _729_/A VGND VGND VPWR VPWR _634_/Y sky130_fd_sc_hd__inv_2
X_703_ _716_/B _703_/B VGND VGND VPWR VPWR _706_/D sky130_fd_sc_hd__xnor2_2
XFILLER_28_83 VGND VGND VPWR VPWR sky130_fd_sc_hd__fill_1
X_565_ _565_/A VGND VGND VPWR VPWR _570_/A sky130_fd_sc_hd__inv_2
X_496_ _476_/B _466_/X _495_/Y VGND VGND VPWR VPWR _506_/A sky130_fd_sc_hd__a21o_4
XPHY_EDGE_ROW_17_Left_54 VGND VGND VPWR VPWR sky130_fd_sc_hd__decap_3
XFILLER_14_85 VGND VGND VPWR VPWR sky130_fd_sc_hd__decap_3
XFILLER_30_62 VGND VGND VPWR VPWR sky130_fd_sc_hd__fill_2
X_617_ _617_/A _739_/C VGND VGND VPWR VPWR _618_/B sky130_fd_sc_hd__xnor2_2
X_548_ _546_/X _547_/Y _522_/Y VGND VGND VPWR VPWR _548_/Y sky130_fd_sc_hd__o21ai_2
X_479_ _479_/A _479_/B VGND VGND VPWR VPWR _479_/Y sky130_fd_sc_hd__xnor2_2
XFILLER_27_128 VGND VGND VPWR VPWR sky130_fd_sc_hd__decap_3
XPHY_EDGE_ROW_2_Left_39 VGND VGND VPWR VPWR sky130_fd_sc_hd__decap_3
XFILLER_2_216 VGND VGND VPWR VPWR sky130_fd_sc_hd__fill_1
XFILLER_18_128 VGND VGND VPWR VPWR sky130_fd_sc_hd__decap_3
X_402_ _401_/A _401_/B _397_/A VGND VGND VPWR VPWR _402_/Y sky130_fd_sc_hd__o21bai_2
XTAP_TAPCELL_ROW_28_178 VGND VPWR sky130_fd_sc_hd__tapvpwrvgnd_1
XFILLER_26_150 VGND VGND VPWR VPWR sky130_fd_sc_hd__decap_3
XFILLER_17_161 VGND VGND VPWR VPWR sky130_fd_sc_hd__decap_3
XFILLER_17_172 VGND VGND VPWR VPWR sky130_fd_sc_hd__decap_3
XTAP_TAPCELL_ROW_19_145 VGND VPWR sky130_fd_sc_hd__tapvpwrvgnd_1
XFILLER_32_175 VGND VGND VPWR VPWR sky130_fd_sc_hd__decap_3
XFILLER_23_186 VGND VGND VPWR VPWR sky130_fd_sc_hd__decap_3
XFILLER_23_131 VGND VGND VPWR VPWR sky130_fd_sc_hd__decap_3
XFILLER_14_164 VGND VGND VPWR VPWR sky130_fd_sc_hd__decap_3
Xinput14 A[21] VGND VGND VPWR VPWR _445_/A sky130_fd_sc_hd__clkdlybuf4s25_1
Xinput25 A[31] VGND VGND VPWR VPWR _554_/B sky130_fd_sc_hd__clkdlybuf4s25_1
Xinput36 B[12] VGND VGND VPWR VPWR _729_/B sky130_fd_sc_hd__buf_6
Xinput47 B[22] VGND VGND VPWR VPWR _455_/B sky130_fd_sc_hd__clkdlybuf4s25_1
Xinput58 B[3] VGND VGND VPWR VPWR _691_/B sky130_fd_sc_hd__dlymetal6s2s_1
XFILLER_20_123 VGND VGND VPWR VPWR sky130_fd_sc_hd__decap_3
XTAP_TAPCELL_ROW_30_184 VGND VPWR sky130_fd_sc_hd__tapvpwrvgnd_1
XFILLER_20_178 VGND VGND VPWR VPWR sky130_fd_sc_hd__decap_3
XTAP_TAPCELL_ROW_21_151 VGND VPWR sky130_fd_sc_hd__tapvpwrvgnd_1
XFILLER_7_116 VGND VGND VPWR VPWR sky130_fd_sc_hd__decap_3
XFILLER_22_52 VGND VGND VPWR VPWR sky130_fd_sc_hd__decap_3
XPHY_EDGE_ROW_5_Left_42 VGND VGND VPWR VPWR sky130_fd_sc_hd__decap_3
XFILLER_7_149 VGND VGND VPWR VPWR sky130_fd_sc_hd__decap_3
XFILLER_34_215 VGND VGND VPWR VPWR sky130_fd_sc_hd__fill_2
XFILLER_8_76 VGND VGND VPWR VPWR sky130_fd_sc_hd__decap_3
XFILLER_25_215 VGND VGND VPWR VPWR sky130_fd_sc_hd__fill_2
XFILLER_4_119 VGND VGND VPWR VPWR sky130_fd_sc_hd__decap_3
X_650_ _650_/A _650_/B VGND VGND VPWR VPWR _650_/Y sky130_fd_sc_hd__nand2_2
XPHY_EDGE_ROW_31_Left_68 VGND VGND VPWR VPWR sky130_fd_sc_hd__decap_3
XFILLER_17_63 VGND VGND VPWR VPWR sky130_fd_sc_hd__decap_3
XFILLER_17_96 VGND VGND VPWR VPWR sky130_fd_sc_hd__decap_3
X_581_ _692_/B _581_/B _694_/A VGND VGND VPWR VPWR _581_/X sky130_fd_sc_hd__and3b_2
XFILLER_33_95 VGND VGND VPWR VPWR sky130_fd_sc_hd__decap_3
XFILLER_3_196 VGND VGND VPWR VPWR sky130_fd_sc_hd__decap_3
Xmax_cap100 _436_/A VGND VGND VPWR VPWR _457_/A sky130_fd_sc_hd__buf_8
XFILLER_0_166 VGND VGND VPWR VPWR sky130_fd_sc_hd__fill_2
XFILLER_0_188 VGND VGND VPWR VPWR sky130_fd_sc_hd__decap_3
X_633_ _633_/A _633_/B VGND VGND VPWR VPWR _633_/Y sky130_fd_sc_hd__xnor2_2
X_702_ _702_/A _723_/B VGND VGND VPWR VPWR _706_/C sky130_fd_sc_hd__xnor2_2
X_564_ _564_/A _564_/B VGND VGND VPWR VPWR _564_/Y sky130_fd_sc_hd__xnor2_2
X_495_ _667_/X _493_/Y _494_/X VGND VGND VPWR VPWR _495_/Y sky130_fd_sc_hd__a21oi_2
XFILLER_5_11 VGND VGND VPWR VPWR sky130_fd_sc_hd__fill_1
XFILLER_5_66 VGND VGND VPWR VPWR sky130_fd_sc_hd__decap_3
XFILLER_14_97 VGND VGND VPWR VPWR sky130_fd_sc_hd__decap_3
XFILLER_30_41 VGND VGND VPWR VPWR sky130_fd_sc_hd__fill_2
XFILLER_30_85 VGND VGND VPWR VPWR sky130_fd_sc_hd__decap_3
X_547_ _539_/B _541_/Y _528_/A _561_/A VGND VGND VPWR VPWR _547_/Y sky130_fd_sc_hd__a211oi_2
X_616_ _365_/Y _616_/A2 _615_/X VGND VGND VPWR VPWR _623_/S sky130_fd_sc_hd__a21oi_4
XPHY_EDGE_ROW_34_Left_71 VGND VGND VPWR VPWR sky130_fd_sc_hd__decap_3
XFILLER_36_129 VGND VGND VPWR VPWR sky130_fd_sc_hd__fill_2
XFILLER_29_181 VGND VGND VPWR VPWR sky130_fd_sc_hd__decap_3
X_478_ _586_/B _494_/B VGND VGND VPWR VPWR _479_/B sky130_fd_sc_hd__xnor2_2
XFILLER_35_195 VGND VGND VPWR VPWR sky130_fd_sc_hd__decap_3
X_401_ _401_/A _401_/B VGND VGND VPWR VPWR _401_/Y sky130_fd_sc_hd__nand2_2
XFILLER_26_173 VGND VGND VPWR VPWR sky130_fd_sc_hd__fill_1
XFILLER_25_85 VGND VGND VPWR VPWR sky130_fd_sc_hd__decap_3
XFILLER_25_41 VGND VGND VPWR VPWR sky130_fd_sc_hd__decap_3
Xrebuffer171 rebuffer172/X VGND VGND VPWR VPWR _588_/B sky130_fd_sc_hd__buf_8
Xrebuffer160 _418_/A VGND VGND VPWR VPWR _425_/A3 sky130_fd_sc_hd__buf_2
XFILLER_2_45 VGND VGND VPWR VPWR sky130_fd_sc_hd__fill_2
XFILLER_2_12 VGND VGND VPWR VPWR sky130_fd_sc_hd__fill_1
XFILLER_17_140 VGND VGND VPWR VPWR sky130_fd_sc_hd__decap_3
XTAP_TAPCELL_ROW_19_146 VGND VPWR sky130_fd_sc_hd__tapvpwrvgnd_1
XFILLER_32_187 VGND VGND VPWR VPWR sky130_fd_sc_hd__fill_2
XTAP_TAPCELL_ROW_33_193 VGND VPWR sky130_fd_sc_hd__tapvpwrvgnd_1
XFILLER_14_121 VGND VGND VPWR VPWR sky130_fd_sc_hd__decap_3
XFILLER_36_73 VGND VGND VPWR VPWR sky130_fd_sc_hd__fill_2
XFILLER_14_176 VGND VGND VPWR VPWR sky130_fd_sc_hd__decap_3
Xinput15 A[22] VGND VGND VPWR VPWR _458_/B sky130_fd_sc_hd__clkdlybuf4s25_1
Xinput26 A[3] VGND VGND VPWR VPWR _691_/A sky130_fd_sc_hd__clkdlybuf4s25_1
Xinput37 B[13] VGND VGND VPWR VPWR _728_/B sky130_fd_sc_hd__buf_4
Xinput48 B[23] VGND VGND VPWR VPWR _468_/B sky130_fd_sc_hd__clkdlybuf4s25_1
Xinput59 B[4] VGND VGND VPWR VPWR _591_/A sky130_fd_sc_hd__clkbuf_2
XFILLER_20_135 VGND VGND VPWR VPWR sky130_fd_sc_hd__decap_3
XFILLER_20_102 VGND VGND VPWR VPWR sky130_fd_sc_hd__decap_3
XTAP_TAPCELL_ROW_30_185 VGND VPWR sky130_fd_sc_hd__tapvpwrvgnd_1
XFILLER_11_113 VGND VGND VPWR VPWR sky130_fd_sc_hd__decap_3
XTAP_TAPCELL_ROW_21_152 VGND VPWR sky130_fd_sc_hd__tapvpwrvgnd_1
XFILLER_22_64 VGND VGND VPWR VPWR sky130_fd_sc_hd__decap_3
XFILLER_8_88 VGND VGND VPWR VPWR sky130_fd_sc_hd__decap_3
XFILLER_6_194 VGND VGND VPWR VPWR sky130_fd_sc_hd__fill_2
XTAP_TAPCELL_ROW_35_200 VGND VPWR sky130_fd_sc_hd__tapvpwrvgnd_1
X_580_ _692_/A _692_/B _581_/B VGND VGND VPWR VPWR _583_/B sky130_fd_sc_hd__and3_2
XFILLER_16_216 VGND VGND VPWR VPWR sky130_fd_sc_hd__fill_1
XFILLER_17_53 VGND VGND VPWR VPWR sky130_fd_sc_hd__decap_3
XFILLER_17_75 VGND VGND VPWR VPWR sky130_fd_sc_hd__fill_1
XFILLER_33_30 VGND VGND VPWR VPWR sky130_fd_sc_hd__decap_3
XFILLER_3_175 VGND VGND VPWR VPWR sky130_fd_sc_hd__decap_3
XFILLER_3_131 VGND VGND VPWR VPWR sky130_fd_sc_hd__decap_3
Xmax_cap101 _622_/A VGND VGND VPWR VPWR _561_/A sky130_fd_sc_hd__buf_6
XFILLER_13_208 VGND VGND VPWR VPWR sky130_fd_sc_hd__fill_1
XPHY_EDGE_ROW_17_Right_17 VGND VGND VPWR VPWR sky130_fd_sc_hd__decap_3
XPHY_EDGE_ROW_26_Right_26 VGND VGND VPWR VPWR sky130_fd_sc_hd__decap_3
X_563_ _563_/A _563_/B _563_/C _563_/D VGND VGND VPWR VPWR _564_/A sky130_fd_sc_hd__and4_2
X_632_ _648_/A _730_/D VGND VGND VPWR VPWR _633_/B sky130_fd_sc_hd__xnor2_4
X_701_ _701_/A _713_/A VGND VGND VPWR VPWR _706_/B sky130_fd_sc_hd__xnor2_4
XFILLER_28_85 VGND VGND VPWR VPWR sky130_fd_sc_hd__decap_3
XFILLER_28_74 VGND VGND VPWR VPWR sky130_fd_sc_hd__decap_3
X_494_ _666_/A _494_/B _494_/C VGND VGND VPWR VPWR _494_/X sky130_fd_sc_hd__and3_2
XPHY_EDGE_ROW_35_Right_35 VGND VGND VPWR VPWR sky130_fd_sc_hd__decap_3
XFILLER_14_76 VGND VGND VPWR VPWR sky130_fd_sc_hd__decap_3
XFILLER_30_97 VGND VGND VPWR VPWR sky130_fd_sc_hd__decap_3
XFILLER_30_53 VGND VGND VPWR VPWR sky130_fd_sc_hd__decap_3
X_546_ _532_/A _532_/B _539_/B _541_/A _667_/X VGND VGND VPWR VPWR _546_/X sky130_fd_sc_hd__o221a_2
X_615_ _365_/Y _611_/X _613_/B VGND VGND VPWR VPWR _615_/X sky130_fd_sc_hd__o21a_2
X_477_ _477_/A _477_/B VGND VGND VPWR VPWR _494_/B sky130_fd_sc_hd__xnor2_2
XFILLER_27_119 VGND VGND VPWR VPWR sky130_fd_sc_hd__decap_3
XFILLER_4_9 VGND VGND VPWR VPWR sky130_fd_sc_hd__decap_3
XFILLER_18_119 VGND VGND VPWR VPWR sky130_fd_sc_hd__decap_3
X_400_ _414_/B _417_/A VGND VGND VPWR VPWR _423_/D sky130_fd_sc_hd__xnor2_2
XFILLER_26_141 VGND VGND VPWR VPWR sky130_fd_sc_hd__decap_3
XFILLER_25_53 VGND VGND VPWR VPWR sky130_fd_sc_hd__decap_3
Xrebuffer150 _611_/X VGND VGND VPWR VPWR _616_/A2 sky130_fd_sc_hd__buf_4
Xrebuffer172 _589_/B VGND VGND VPWR VPWR rebuffer172/X sky130_fd_sc_hd__buf_6
XFILLER_17_152 VGND VGND VPWR VPWR sky130_fd_sc_hd__decap_3
XFILLER_17_185 VGND VGND VPWR VPWR sky130_fd_sc_hd__decap_3
X_529_ _648_/A _529_/B VGND VGND VPWR VPWR _530_/B sky130_fd_sc_hd__xnor2_2
XFILLER_32_155 VGND VGND VPWR VPWR sky130_fd_sc_hd__decap_3
XFILLER_23_122 VGND VGND VPWR VPWR sky130_fd_sc_hd__decap_3
XFILLER_23_111 VGND VGND VPWR VPWR sky130_fd_sc_hd__fill_1
XTAP_TAPCELL_ROW_33_194 VGND VPWR sky130_fd_sc_hd__tapvpwrvgnd_1
XFILLER_23_155 VGND VGND VPWR VPWR sky130_fd_sc_hd__decap_3
XFILLER_11_55 VGND VGND VPWR VPWR sky130_fd_sc_hd__fill_1
XFILLER_11_66 VGND VGND VPWR VPWR sky130_fd_sc_hd__decap_3
XFILLER_2_6 VGND VGND VPWR VPWR sky130_fd_sc_hd__decap_3
XFILLER_14_100 VGND VGND VPWR VPWR sky130_fd_sc_hd__decap_3
XTAP_TAPCELL_ROW_24_161 VGND VPWR sky130_fd_sc_hd__tapvpwrvgnd_1
Xinput16 A[23] VGND VGND VPWR VPWR _471_/A sky130_fd_sc_hd__clkdlybuf4s25_1
Xinput27 A[4] VGND VGND VPWR VPWR _703_/B sky130_fd_sc_hd__clkbuf_2
Xinput38 B[14] VGND VGND VPWR VPWR _726_/A sky130_fd_sc_hd__clkbuf_2
Xinput49 B[24] VGND VGND VPWR VPWR _477_/A sky130_fd_sc_hd__clkdlybuf4s25_1
XFILLER_35_6 VGND VGND VPWR VPWR sky130_fd_sc_hd__decap_3
XFILLER_20_158 VGND VGND VPWR VPWR sky130_fd_sc_hd__decap_3
XFILLER_20_114 VGND VGND VPWR VPWR sky130_fd_sc_hd__decap_3
XFILLER_11_169 VGND VGND VPWR VPWR sky130_fd_sc_hd__decap_3
XTAP_TAPCELL_ROW_21_153 VGND VPWR sky130_fd_sc_hd__tapvpwrvgnd_1
XFILLER_7_107 VGND VGND VPWR VPWR sky130_fd_sc_hd__decap_3
XFILLER_22_32 VGND VGND VPWR VPWR sky130_fd_sc_hd__fill_2
XFILLER_0_3 VGND VGND VPWR VPWR sky130_fd_sc_hd__decap_3
XFILLER_34_206 VGND VGND VPWR VPWR sky130_fd_sc_hd__decap_3
XTAP_TAPCELL_ROW_12_120 VGND VPWR sky130_fd_sc_hd__tapvpwrvgnd_1
XFILLER_33_3 VGND VGND VPWR VPWR sky130_fd_sc_hd__decap_3
XTAP_TAPCELL_ROW_35_201 VGND VPWR sky130_fd_sc_hd__tapvpwrvgnd_1
XFILLER_33_42 VGND VGND VPWR VPWR sky130_fd_sc_hd__decap_3
XFILLER_31_209 VGND VGND VPWR VPWR sky130_fd_sc_hd__fill_2
XFILLER_3_143 VGND VGND VPWR VPWR sky130_fd_sc_hd__fill_1
XFILLER_3_187 VGND VGND VPWR VPWR sky130_fd_sc_hd__decap_3
Xmax_cap102 _667_/X VGND VGND VPWR VPWR _732_/S sky130_fd_sc_hd__buf_8
X_700_ _724_/A _709_/B VGND VGND VPWR VPWR _707_/B sky130_fd_sc_hd__and2b_2
X_562_ _550_/A _550_/B _436_/A _656_/A VGND VGND VPWR VPWR _563_/D sky130_fd_sc_hd__o211ai_2
X_631_ _631_/A _631_/B VGND VGND VPWR VPWR _633_/A sky130_fd_sc_hd__nand2_4
X_493_ _494_/B _494_/C VGND VGND VPWR VPWR _493_/Y sky130_fd_sc_hd__nor2_2
XFILLER_5_57 VGND VGND VPWR VPWR sky130_fd_sc_hd__decap_3
XFILLER_5_35 VGND VGND VPWR VPWR sky130_fd_sc_hd__decap_3
XFILLER_14_88 VGND VGND VPWR VPWR sky130_fd_sc_hd__decap_3
XFILLER_30_32 VGND VGND VPWR VPWR sky130_fd_sc_hd__decap_3
XFILLER_29_172 VGND VGND VPWR VPWR sky130_fd_sc_hd__decap_3
X_545_ _541_/A _537_/X _544_/X _540_/X VGND VGND VPWR VPWR _656_/C sky130_fd_sc_hd__o211a_4
X_614_ _614_/A _614_/B VGND VGND VPWR VPWR _614_/Y sky130_fd_sc_hd__xnor2_2
X_476_ _476_/A _476_/B VGND VGND VPWR VPWR _479_/A sky130_fd_sc_hd__nand2_8
XFILLER_35_164 VGND VGND VPWR VPWR sky130_fd_sc_hd__decap_3
XFILLER_35_131 VGND VGND VPWR VPWR sky130_fd_sc_hd__fill_2
XFILLER_26_197 VGND VGND VPWR VPWR sky130_fd_sc_hd__fill_1
XFILLER_26_153 VGND VGND VPWR VPWR sky130_fd_sc_hd__decap_3
XFILLER_25_32 VGND VGND VPWR VPWR sky130_fd_sc_hd__decap_3
Xrebuffer173 _591_/B VGND VGND VPWR VPWR _593_/A2 sky130_fd_sc_hd__buf_2
Xrebuffer140 _731_/C VGND VGND VPWR VPWR _730_/C sky130_fd_sc_hd__buf_2
XFILLER_17_164 VGND VGND VPWR VPWR sky130_fd_sc_hd__decap_3
XFILLER_17_175 VGND VGND VPWR VPWR sky130_fd_sc_hd__fill_2
X_528_ _528_/A _528_/B VGND VGND VPWR VPWR _529_/B sky130_fd_sc_hd__nor2_2
X_459_ _457_/Y _458_/X _459_/S VGND VGND VPWR VPWR _460_/B sky130_fd_sc_hd__mux2_4
XFILLER_32_178 VGND VGND VPWR VPWR sky130_fd_sc_hd__decap_3
XFILLER_23_134 VGND VGND VPWR VPWR sky130_fd_sc_hd__decap_3
XTAP_TAPCELL_ROW_33_195 VGND VPWR sky130_fd_sc_hd__tapvpwrvgnd_1
XFILLER_23_189 VGND VGND VPWR VPWR sky130_fd_sc_hd__decap_3
XFILLER_11_34 VGND VGND VPWR VPWR sky130_fd_sc_hd__decap_3
XFILLER_14_112 VGND VGND VPWR VPWR sky130_fd_sc_hd__decap_3
XFILLER_14_156 VGND VGND VPWR VPWR sky130_fd_sc_hd__fill_1
XFILLER_14_167 VGND VGND VPWR VPWR sky130_fd_sc_hd__decap_3
XTAP_TAPCELL_ROW_24_162 VGND VPWR sky130_fd_sc_hd__tapvpwrvgnd_1
Xinput17 A[24] VGND VGND VPWR VPWR _477_/B sky130_fd_sc_hd__clkdlybuf4s25_1
Xinput28 A[5] VGND VGND VPWR VPWR _713_/A sky130_fd_sc_hd__buf_4
Xinput39 B[15] VGND VGND VPWR VPWR _727_/B sky130_fd_sc_hd__buf_4
XFILLER_9_160 VGND VGND VPWR VPWR sky130_fd_sc_hd__decap_3
XFILLER_20_126 VGND VGND VPWR VPWR sky130_fd_sc_hd__decap_3
XFILLER_3_90 VGND VGND VPWR VPWR sky130_fd_sc_hd__decap_3
XFILLER_7_119 VGND VGND VPWR VPWR sky130_fd_sc_hd__fill_2
XFILLER_22_55 VGND VGND VPWR VPWR sky130_fd_sc_hd__decap_3
XFILLER_19_215 VGND VGND VPWR VPWR sky130_fd_sc_hd__fill_2
XTAP_TAPCELL_ROW_12_121 VGND VPWR sky130_fd_sc_hd__tapvpwrvgnd_1
XFILLER_6_163 VGND VGND VPWR VPWR sky130_fd_sc_hd__decap_3
XTAP_TAPCELL_ROW_35_202 VGND VPWR sky130_fd_sc_hd__tapvpwrvgnd_1
XFILLER_17_66 VGND VGND VPWR VPWR sky130_fd_sc_hd__decap_3
XFILLER_17_99 VGND VGND VPWR VPWR sky130_fd_sc_hd__decap_3
XPHY_EDGE_ROW_9_Left_46 VGND VGND VPWR VPWR sky130_fd_sc_hd__decap_3
XFILLER_33_98 VGND VGND VPWR VPWR sky130_fd_sc_hd__decap_3
XFILLER_3_122 VGND VGND VPWR VPWR sky130_fd_sc_hd__fill_1
XFILLER_3_111 VGND VGND VPWR VPWR sky130_fd_sc_hd__fill_1
XFILLER_0_80 VGND VGND VPWR VPWR sky130_fd_sc_hd__decap_3
XPHY_EDGE_ROW_3_Right_3 VGND VGND VPWR VPWR sky130_fd_sc_hd__decap_3
XFILLER_0_147 VGND VGND VPWR VPWR sky130_fd_sc_hd__decap_3
X_630_ _630_/A1 _628_/B _630_/B1 VGND VGND VPWR VPWR _631_/B sky130_fd_sc_hd__a21o_4
XFILLER_28_43 VGND VGND VPWR VPWR sky130_fd_sc_hd__decap_3
XFILLER_28_32 VGND VGND VPWR VPWR sky130_fd_sc_hd__fill_1
X_561_ _561_/A _656_/A _561_/C _656_/B VGND VGND VPWR VPWR _563_/B sky130_fd_sc_hd__or4_4
X_492_ _490_/X _477_/B _491_/X _489_/A VGND VGND VPWR VPWR _492_/Y sky130_fd_sc_hd__a22oi_2
XFILLER_5_69 VGND VGND VPWR VPWR sky130_fd_sc_hd__decap_3
XFILLER_14_12 VGND VGND VPWR VPWR sky130_fd_sc_hd__fill_2
XFILLER_30_88 VGND VGND VPWR VPWR sky130_fd_sc_hd__decap_3
X_613_ _737_/B _613_/B VGND VGND VPWR VPWR _614_/B sky130_fd_sc_hd__xnor2_2
XFILLER_29_184 VGND VGND VPWR VPWR sky130_fd_sc_hd__decap_3
X_544_ _533_/B _533_/C _542_/Y _543_/X VGND VGND VPWR VPWR _544_/X sky130_fd_sc_hd__a2bb2o_2
X_475_ _467_/X _420_/A _470_/Y _474_/X VGND VGND VPWR VPWR _476_/B sky130_fd_sc_hd__o2bb2a_4
XFILLER_35_198 VGND VGND VPWR VPWR sky130_fd_sc_hd__decap_3
XFILLER_26_110 VGND VGND VPWR VPWR sky130_fd_sc_hd__decap_3
XFILLER_25_88 VGND VGND VPWR VPWR sky130_fd_sc_hd__fill_2
XFILLER_25_66 VGND VGND VPWR VPWR sky130_fd_sc_hd__decap_3
XFILLER_25_44 VGND VGND VPWR VPWR sky130_fd_sc_hd__fill_1
Xrebuffer141 _656_/C VGND VGND VPWR VPWR _561_/C sky130_fd_sc_hd__buf_2
Xrebuffer130 _367_/X VGND VGND VPWR VPWR _630_/A1 sky130_fd_sc_hd__buf_4
XPHY_EDGE_ROW_22_Left_59 VGND VGND VPWR VPWR sky130_fd_sc_hd__decap_3
XFILLER_17_143 VGND VGND VPWR VPWR sky130_fd_sc_hd__decap_3
X_527_ _532_/A _533_/B VGND VGND VPWR VPWR _528_/B sky130_fd_sc_hd__nor2_2
X_458_ _561_/A _458_/B VGND VGND VPWR VPWR _458_/X sky130_fd_sc_hd__or2_2
X_389_ _387_/Y _423_/B _561_/A VGND VGND VPWR VPWR _389_/X sky130_fd_sc_hd__mux2_2
XFILLER_32_124 VGND VGND VPWR VPWR sky130_fd_sc_hd__decap_3
XFILLER_23_113 VGND VGND VPWR VPWR sky130_fd_sc_hd__decap_3
XFILLER_23_102 VGND VGND VPWR VPWR sky130_fd_sc_hd__decap_3
XFILLER_11_57 VGND VGND VPWR VPWR sky130_fd_sc_hd__decap_3
XFILLER_36_32 VGND VGND VPWR VPWR sky130_fd_sc_hd__fill_1
XFILLER_14_124 VGND VGND VPWR VPWR sky130_fd_sc_hd__fill_2
XFILLER_14_146 VGND VGND VPWR VPWR sky130_fd_sc_hd__fill_2
Xinput18 A[25] VGND VGND VPWR VPWR _489_/A sky130_fd_sc_hd__dlymetal6s2s_1
XTAP_TAPCELL_ROW_24_163 VGND VPWR sky130_fd_sc_hd__tapvpwrvgnd_1
Xinput29 A[6] VGND VGND VPWR VPWR _723_/B sky130_fd_sc_hd__dlymetal6s2s_1
XTAP_TAPCELL_ROW_15_130 VGND VPWR sky130_fd_sc_hd__tapvpwrvgnd_1
XFILLER_20_105 VGND VGND VPWR VPWR sky130_fd_sc_hd__decap_3
XFILLER_20_138 VGND VGND VPWR VPWR sky130_fd_sc_hd__fill_2
XFILLER_11_116 VGND VGND VPWR VPWR sky130_fd_sc_hd__decap_3
XFILLER_22_67 VGND VGND VPWR VPWR sky130_fd_sc_hd__decap_3
XFILLER_10_160 VGND VGND VPWR VPWR sky130_fd_sc_hd__fill_2
XFILLER_10_193 VGND VGND VPWR VPWR sky130_fd_sc_hd__decap_3
XTAP_TAPCELL_ROW_12_122 VGND VPWR sky130_fd_sc_hd__tapvpwrvgnd_1
XFILLER_8_25 VGND VGND VPWR VPWR sky130_fd_sc_hd__decap_3
XPHY_EDGE_ROW_25_Left_62 VGND VGND VPWR VPWR sky130_fd_sc_hd__decap_3
XFILLER_19_3 VGND VGND VPWR VPWR sky130_fd_sc_hd__decap_3
XFILLER_33_33 VGND VGND VPWR VPWR sky130_fd_sc_hd__decap_3
XFILLER_3_178 VGND VGND VPWR VPWR sky130_fd_sc_hd__decap_3
XFILLER_3_167 VGND VGND VPWR VPWR sky130_fd_sc_hd__fill_1
XFILLER_3_134 VGND VGND VPWR VPWR sky130_fd_sc_hd__fill_1
XFILLER_0_126 VGND VGND VPWR VPWR sky130_fd_sc_hd__decap_3
XFILLER_0_137 VGND VGND VPWR VPWR sky130_fd_sc_hd__decap_3
X_560_ _560_/A _657_/A _560_/C _656_/B VGND VGND VPWR VPWR _563_/C sky130_fd_sc_hd__or4_4
XFILLER_28_88 VGND VGND VPWR VPWR sky130_fd_sc_hd__decap_3
XFILLER_28_77 VGND VGND VPWR VPWR sky130_fd_sc_hd__decap_3
XFILLER_28_22 VGND VGND VPWR VPWR sky130_fd_sc_hd__fill_2
X_491_ _506_/D _491_/B VGND VGND VPWR VPWR _491_/X sky130_fd_sc_hd__xor2_2
X_689_ _689_/A _565_/A VGND VGND VPWR VPWR _689_/X sky130_fd_sc_hd__or2b_4
XPHY_EDGE_ROW_13_Right_13 VGND VGND VPWR VPWR sky130_fd_sc_hd__decap_3
XPHY_EDGE_ROW_22_Right_22 VGND VGND VPWR VPWR sky130_fd_sc_hd__decap_3
XPHY_EDGE_ROW_31_Right_31 VGND VGND VPWR VPWR sky130_fd_sc_hd__decap_3
XFILLER_14_79 VGND VGND VPWR VPWR sky130_fd_sc_hd__decap_3
XFILLER_30_56 VGND VGND VPWR VPWR sky130_fd_sc_hd__decap_3
X_543_ _539_/B _541_/A _661_/A _532_/A VGND VGND VPWR VPWR _543_/X sky130_fd_sc_hd__a211o_2
X_612_ _617_/A _737_/A VGND VGND VPWR VPWR _613_/B sky130_fd_sc_hd__xnor2_2
X_474_ _458_/B _448_/X _472_/X _473_/Y VGND VGND VPWR VPWR _474_/X sky130_fd_sc_hd__o2bb2a_2
XFILLER_6_91 VGND VGND VPWR VPWR sky130_fd_sc_hd__decap_3
XFILLER_26_144 VGND VGND VPWR VPWR sky130_fd_sc_hd__decap_3
XFILLER_26_122 VGND VGND VPWR VPWR sky130_fd_sc_hd__decap_3
XFILLER_25_23 VGND VGND VPWR VPWR sky130_fd_sc_hd__decap_3
Xrebuffer131 _560_/C VGND VGND VPWR VPWR _550_/A sky130_fd_sc_hd__buf_2
XFILLER_17_111 VGND VGND VPWR VPWR sky130_fd_sc_hd__fill_1
XFILLER_17_122 VGND VGND VPWR VPWR sky130_fd_sc_hd__decap_3
XFILLER_17_155 VGND VGND VPWR VPWR sky130_fd_sc_hd__decap_3
XFILLER_17_188 VGND VGND VPWR VPWR sky130_fd_sc_hd__decap_3
X_526_ _532_/A _533_/B VGND VGND VPWR VPWR _528_/A sky130_fd_sc_hd__and2_2
XTAP_TAPCELL_ROW_27_172 VGND VPWR sky130_fd_sc_hd__tapvpwrvgnd_1
X_457_ _457_/A _458_/B VGND VGND VPWR VPWR _457_/Y sky130_fd_sc_hd__nand2_2
X_388_ _388_/A _388_/B VGND VGND VPWR VPWR _423_/B sky130_fd_sc_hd__or2_2
XFILLER_32_169 VGND VGND VPWR VPWR sky130_fd_sc_hd__decap_3
XFILLER_32_158 VGND VGND VPWR VPWR sky130_fd_sc_hd__fill_1
XFILLER_23_158 VGND VGND VPWR VPWR sky130_fd_sc_hd__fill_1
XFILLER_23_125 VGND VGND VPWR VPWR sky130_fd_sc_hd__decap_3
XFILLER_11_69 VGND VGND VPWR VPWR sky130_fd_sc_hd__decap_3
XFILLER_2_9 VGND VGND VPWR VPWR sky130_fd_sc_hd__decap_3
XFILLER_14_103 VGND VGND VPWR VPWR sky130_fd_sc_hd__decap_3
XFILLER_14_136 VGND VGND VPWR VPWR sky130_fd_sc_hd__decap_3
Xinput19 A[26] VGND VGND VPWR VPWR _505_/A sky130_fd_sc_hd__clkdlybuf4s25_1
XTAP_TAPCELL_ROW_24_164 VGND VPWR sky130_fd_sc_hd__tapvpwrvgnd_1
XFILLER_35_9 VGND VGND VPWR VPWR sky130_fd_sc_hd__fill_1
X_509_ _509_/A _521_/C VGND VGND VPWR VPWR _509_/Y sky130_fd_sc_hd__xnor2_4
XTAP_TAPCELL_ROW_15_131 VGND VPWR sky130_fd_sc_hd__tapvpwrvgnd_1
XFILLER_20_117 VGND VGND VPWR VPWR sky130_fd_sc_hd__decap_3
XFILLER_9_151 VGND VGND VPWR VPWR sky130_fd_sc_hd__decap_3
XFILLER_3_81 VGND VGND VPWR VPWR sky130_fd_sc_hd__decap_3
XFILLER_3_70 VGND VGND VPWR VPWR sky130_fd_sc_hd__decap_3
XFILLER_0_6 VGND VGND VPWR VPWR sky130_fd_sc_hd__decap_3
XFILLER_34_209 VGND VGND VPWR VPWR sky130_fd_sc_hd__decap_3
XFILLER_10_150 VGND VGND VPWR VPWR sky130_fd_sc_hd__fill_2
XFILLER_33_6 VGND VGND VPWR VPWR sky130_fd_sc_hd__fill_2
XFILLER_17_35 VGND VGND VPWR VPWR sky130_fd_sc_hd__fill_2
XFILLER_17_57 VGND VGND VPWR VPWR sky130_fd_sc_hd__decap_3
XFILLER_33_89 VGND VGND VPWR VPWR sky130_fd_sc_hd__decap_3
XFILLER_33_45 VGND VGND VPWR VPWR sky130_fd_sc_hd__decap_3
XFILLER_3_113 VGND VGND VPWR VPWR sky130_fd_sc_hd__decap_3
XFILLER_0_60 VGND VGND VPWR VPWR sky130_fd_sc_hd__fill_1
XFILLER_0_93 VGND VGND VPWR VPWR sky130_fd_sc_hd__decap_3
XFILLER_9_91 VGND VGND VPWR VPWR sky130_fd_sc_hd__decap_3
X_490_ _490_/A1 _487_/X _489_/X _488_/X VGND VGND VPWR VPWR _490_/X sky130_fd_sc_hd__a22o_4
XFILLER_5_38 VGND VGND VPWR VPWR sky130_fd_sc_hd__fill_2
X_688_ _684_/Y _683_/Y _732_/S _687_/X VGND VGND VPWR VPWR _688_/X sky130_fd_sc_hd__o31a_4
XFILLER_30_35 VGND VGND VPWR VPWR sky130_fd_sc_hd__decap_3
X_542_ _539_/B _541_/Y _661_/A _532_/A VGND VGND VPWR VPWR _542_/Y sky130_fd_sc_hd__o211ai_2
X_611_ _721_/X _708_/Y _725_/X VGND VGND VPWR VPWR _611_/X sky130_fd_sc_hd__and3_4
X_473_ _468_/B _471_/A _423_/A _455_/B VGND VGND VPWR VPWR _473_/Y sky130_fd_sc_hd__a211oi_2
XFILLER_29_175 VGND VGND VPWR VPWR sky130_fd_sc_hd__decap_3
XFILLER_29_131 VGND VGND VPWR VPWR sky130_fd_sc_hd__decap_3
XFILLER_35_167 VGND VGND VPWR VPWR sky130_fd_sc_hd__fill_1
XFILLER_26_156 VGND VGND VPWR VPWR sky130_fd_sc_hd__fill_2
XFILLER_25_35 VGND VGND VPWR VPWR sky130_fd_sc_hd__decap_3
Xrebuffer132 _656_/B VGND VGND VPWR VPWR _550_/B sky130_fd_sc_hd__buf_6
Xrebuffer121 _436_/C VGND VGND VPWR VPWR _437_/C sky130_fd_sc_hd__buf_8
XFILLER_1_211 VGND VGND VPWR VPWR sky130_fd_sc_hd__decap_3
XFILLER_17_167 VGND VGND VPWR VPWR sky130_fd_sc_hd__fill_1
X_525_ _532_/B VGND VGND VPWR VPWR _533_/B sky130_fd_sc_hd__inv_2
X_456_ _454_/X _455_/Y _459_/S VGND VGND VPWR VPWR _460_/A sky130_fd_sc_hd__mux2_4
XTAP_TAPCELL_ROW_27_173 VGND VPWR sky130_fd_sc_hd__tapvpwrvgnd_1
X_387_ _387_/A VGND VGND VPWR VPWR _387_/Y sky130_fd_sc_hd__inv_2
XTAP_TAPCELL_ROW_18_140 VGND VPWR sky130_fd_sc_hd__tapvpwrvgnd_1
XFILLER_23_137 VGND VGND VPWR VPWR sky130_fd_sc_hd__decap_3
XFILLER_11_37 VGND VGND VPWR VPWR sky130_fd_sc_hd__fill_2
XFILLER_14_115 VGND VGND VPWR VPWR sky130_fd_sc_hd__decap_3
X_508_ _508_/A _508_/B _508_/C _507_/X VGND VGND VPWR VPWR _509_/A sky130_fd_sc_hd__or4b_4
X_439_ _441_/B _439_/B VGND VGND VPWR VPWR _439_/Y sky130_fd_sc_hd__xnor2_2
XTAP_TAPCELL_ROW_15_132 VGND VPWR sky130_fd_sc_hd__tapvpwrvgnd_1
XFILLER_20_129 VGND VGND VPWR VPWR sky130_fd_sc_hd__decap_3
XFILLER_9_196 VGND VGND VPWR VPWR sky130_fd_sc_hd__decap_3
XFILLER_9_163 VGND VGND VPWR VPWR sky130_fd_sc_hd__decap_3
XFILLER_3_93 VGND VGND VPWR VPWR sky130_fd_sc_hd__decap_3
XFILLER_22_58 VGND VGND VPWR VPWR sky130_fd_sc_hd__decap_3
XFILLER_22_25 VGND VGND VPWR VPWR sky130_fd_sc_hd__decap_3
XTAP_TAPCELL_ROW_6_100 VGND VPWR sky130_fd_sc_hd__tapvpwrvgnd_1
XFILLER_8_38 VGND VGND VPWR VPWR sky130_fd_sc_hd__decap_3
XFILLER_12_91 VGND VGND VPWR VPWR sky130_fd_sc_hd__decap_3
XFILLER_6_166 VGND VGND VPWR VPWR sky130_fd_sc_hd__fill_1
XFILLER_17_69 VGND VGND VPWR VPWR sky130_fd_sc_hd__decap_3
XFILLER_33_13 VGND VGND VPWR VPWR sky130_fd_sc_hd__decap_3
XFILLER_24_210 VGND VGND VPWR VPWR sky130_fd_sc_hd__decap_3
XFILLER_3_169 VGND VGND VPWR VPWR sky130_fd_sc_hd__decap_3
XFILLER_23_90 VGND VGND VPWR VPWR sky130_fd_sc_hd__decap_3
XFILLER_2_180 VGND VGND VPWR VPWR sky130_fd_sc_hd__decap_3
XFILLER_0_83 VGND VGND VPWR VPWR sky130_fd_sc_hd__fill_1
XFILLER_28_46 VGND VGND VPWR VPWR sky130_fd_sc_hd__fill_2
X_687_ _691_/A _685_/X _686_/X _694_/A VGND VGND VPWR VPWR _687_/X sky130_fd_sc_hd__a211o_2
XPHY_EDGE_ROW_7_Right_7 VGND VGND VPWR VPWR sky130_fd_sc_hd__decap_3
XFILLER_14_59 VGND VGND VPWR VPWR sky130_fd_sc_hd__decap_3
XFILLER_30_25 VGND VGND VPWR VPWR sky130_fd_sc_hd__decap_3
X_610_ _610_/A _610_/B VGND VGND VPWR VPWR _610_/Y sky130_fd_sc_hd__xnor2_2
X_541_ _541_/A VGND VGND VPWR VPWR _541_/Y sky130_fd_sc_hd__inv_2
X_472_ _468_/B _471_/Y _423_/A _455_/B VGND VGND VPWR VPWR _472_/X sky130_fd_sc_hd__o211a_2
XFILLER_29_187 VGND VGND VPWR VPWR sky130_fd_sc_hd__fill_1
X_739_ _739_/A _739_/B _739_/C VGND VGND VPWR VPWR _739_/X sky130_fd_sc_hd__or3_4
XFILLER_35_124 VGND VGND VPWR VPWR sky130_fd_sc_hd__fill_1
XFILLER_35_113 VGND VGND VPWR VPWR sky130_fd_sc_hd__fill_2
XFILLER_6_60 VGND VGND VPWR VPWR sky130_fd_sc_hd__fill_1
XFILLER_26_113 VGND VGND VPWR VPWR sky130_fd_sc_hd__decap_3
XFILLER_25_69 VGND VGND VPWR VPWR sky130_fd_sc_hd__fill_1
Xrebuffer133 _492_/Y VGND VGND VPWR VPWR _506_/C sky130_fd_sc_hd__buf_2
Xrebuffer122 fanout107/X VGND VGND VPWR VPWR _423_/A sky130_fd_sc_hd__buf_2
Xrebuffer199 _647_/Y VGND VGND VPWR VPWR _649_/A sky130_fd_sc_hd__buf_6
XFILLER_17_102 VGND VGND VPWR VPWR sky130_fd_sc_hd__decap_3
XFILLER_17_113 VGND VGND VPWR VPWR sky130_fd_sc_hd__decap_3
XFILLER_17_146 VGND VGND VPWR VPWR sky130_fd_sc_hd__decap_3
X_524_ _533_/C _533_/D VGND VGND VPWR VPWR _530_/A sky130_fd_sc_hd__nand2_2
X_455_ _458_/B _455_/B VGND VGND VPWR VPWR _455_/Y sky130_fd_sc_hd__nand2_2
X_386_ _388_/A _388_/B VGND VGND VPWR VPWR _387_/A sky130_fd_sc_hd__and2_2
XTAP_TAPCELL_ROW_27_174 VGND VPWR sky130_fd_sc_hd__tapvpwrvgnd_1
XFILLER_32_127 VGND VGND VPWR VPWR sky130_fd_sc_hd__decap_3
Xoutput90 _564_/Y VGND VGND VPWR VPWR S[31] sky130_fd_sc_hd__buf_6
XTAP_TAPCELL_ROW_18_141 VGND VPWR sky130_fd_sc_hd__tapvpwrvgnd_1
XFILLER_23_116 VGND VGND VPWR VPWR sky130_fd_sc_hd__decap_3
XFILLER_23_105 VGND VGND VPWR VPWR sky130_fd_sc_hd__decap_3
XFILLER_31_182 VGND VGND VPWR VPWR sky130_fd_sc_hd__fill_2
XFILLER_36_57 VGND VGND VPWR VPWR sky130_fd_sc_hd__fill_2
X_507_ _506_/C _497_/B _506_/D _506_/B VGND VGND VPWR VPWR _507_/X sky130_fd_sc_hd__a211o_2
X_438_ _438_/A _438_/B _438_/C VGND VGND VPWR VPWR _439_/B sky130_fd_sc_hd__nand3_4
X_369_ _736_/B _369_/B _369_/C VGND VGND VPWR VPWR _369_/X sky130_fd_sc_hd__and3b_2
XFILLER_9_131 VGND VGND VPWR VPWR sky130_fd_sc_hd__decap_3
XFILLER_20_108 VGND VGND VPWR VPWR sky130_fd_sc_hd__decap_3
XFILLER_11_119 VGND VGND VPWR VPWR sky130_fd_sc_hd__decap_3
Xfanout110 input65/X VGND VGND VPWR VPWR _694_/A sky130_fd_sc_hd__buf_2
XTAP_TAPCELL_ROW_6_101 VGND VPWR sky130_fd_sc_hd__tapvpwrvgnd_1
XFILLER_10_141 VGND VGND VPWR VPWR sky130_fd_sc_hd__decap_3
XFILLER_12_81 VGND VGND VPWR VPWR sky130_fd_sc_hd__decap_3
XFILLER_33_36 VGND VGND VPWR VPWR sky130_fd_sc_hd__decap_3
XPHY_EDGE_ROW_29_Left_66 VGND VGND VPWR VPWR sky130_fd_sc_hd__decap_3
XFILLER_2_192 VGND VGND VPWR VPWR sky130_fd_sc_hd__decap_3
XFILLER_9_60 VGND VGND VPWR VPWR sky130_fd_sc_hd__decap_3
XFILLER_8_207 VGND VGND VPWR VPWR sky130_fd_sc_hd__fill_1
XFILLER_18_80 VGND VGND VPWR VPWR sky130_fd_sc_hd__decap_3
X_686_ _691_/B _692_/A _692_/B VGND VGND VPWR VPWR _686_/X sky130_fd_sc_hd__and3_2
XFILLER_30_59 VGND VGND VPWR VPWR sky130_fd_sc_hd__decap_3
X_540_ _538_/Y _539_/X _537_/X _541_/A VGND VGND VPWR VPWR _540_/X sky130_fd_sc_hd__a22o_4
XFILLER_29_122 VGND VGND VPWR VPWR sky130_fd_sc_hd__decap_3
X_471_ _471_/A VGND VGND VPWR VPWR _471_/Y sky130_fd_sc_hd__inv_2
X_669_ _729_/B _729_/A VGND VGND VPWR VPWR _669_/X sky130_fd_sc_hd__or2b_2
X_738_ _740_/A _740_/B VGND VGND VPWR VPWR _738_/Y sky130_fd_sc_hd__nor2_2
XPHY_EDGE_ROW_16_Left_53 VGND VGND VPWR VPWR sky130_fd_sc_hd__decap_3
XFILLER_26_147 VGND VGND VPWR VPWR sky130_fd_sc_hd__decap_3
XFILLER_26_125 VGND VGND VPWR VPWR sky130_fd_sc_hd__decap_3
XFILLER_25_26 VGND VGND VPWR VPWR sky130_fd_sc_hd__decap_3
Xrebuffer167 _466_/X VGND VGND VPWR VPWR rebuffer167/X sky130_fd_sc_hd__buf_2
Xrebuffer145 _739_/A VGND VGND VPWR VPWR _490_/A1 sky130_fd_sc_hd__buf_2
Xrebuffer134 _656_/C VGND VGND VPWR VPWR _560_/C sky130_fd_sc_hd__buf_6
Xrebuffer123 _666_/A VGND VGND VPWR VPWR _468_/A sky130_fd_sc_hd__buf_2
XFILLER_1_202 VGND VGND VPWR VPWR sky130_fd_sc_hd__decap_3
XFILLER_17_125 VGND VGND VPWR VPWR sky130_fd_sc_hd__decap_3
XFILLER_17_158 VGND VGND VPWR VPWR sky130_fd_sc_hd__decap_3
XFILLER_17_169 VGND VGND VPWR VPWR sky130_fd_sc_hd__decap_3
X_523_ _466_/X _476_/B _522_/Y VGND VGND VPWR VPWR _533_/D sky130_fd_sc_hd__a21bo_2
XFILLER_15_81 VGND VGND VPWR VPWR sky130_fd_sc_hd__decap_3
XFILLER_15_92 VGND VGND VPWR VPWR sky130_fd_sc_hd__decap_3
X_454_ _458_/B _455_/B VGND VGND VPWR VPWR _454_/X sky130_fd_sc_hd__or2b_2
X_385_ _388_/B _385_/B VGND VGND VPWR VPWR _385_/X sky130_fd_sc_hd__xor2_2
XTAP_TAPCELL_ROW_2_84 VGND VPWR sky130_fd_sc_hd__tapvpwrvgnd_1
Xoutput91 _584_/Y VGND VGND VPWR VPWR S[3] sky130_fd_sc_hd__clkbuf_4
Xoutput80 _452_/Y VGND VGND VPWR VPWR S[22] sky130_fd_sc_hd__buf_6
XTAP_TAPCELL_ROW_18_142 VGND VPWR sky130_fd_sc_hd__tapvpwrvgnd_1
XFILLER_23_128 VGND VGND VPWR VPWR sky130_fd_sc_hd__decap_3
XFILLER_11_17 VGND VGND VPWR VPWR sky130_fd_sc_hd__fill_2
XPHY_EDGE_ROW_1_Left_38 VGND VGND VPWR VPWR sky130_fd_sc_hd__decap_3
XFILLER_36_25 VGND VGND VPWR VPWR sky130_fd_sc_hd__decap_3
XFILLER_14_106 VGND VGND VPWR VPWR sky130_fd_sc_hd__decap_3
XFILLER_14_139 VGND VGND VPWR VPWR sky130_fd_sc_hd__fill_1
XTAP_TAPCELL_ROW_9_110 VGND VPWR sky130_fd_sc_hd__tapvpwrvgnd_1
X_506_ _506_/A _506_/B _506_/C _506_/D VGND VGND VPWR VPWR _508_/B sky130_fd_sc_hd__and4_2
XFILLER_13_172 VGND VGND VPWR VPWR sky130_fd_sc_hd__decap_3
X_437_ _648_/A _437_/B _437_/C VGND VGND VPWR VPWR _438_/C sky130_fd_sc_hd__nand3_2
X_368_ _644_/A _736_/A VGND VGND VPWR VPWR _628_/B sky130_fd_sc_hd__xnor2_2
XFILLER_9_154 VGND VGND VPWR VPWR sky130_fd_sc_hd__decap_3
XFILLER_3_84 VGND VGND VPWR VPWR sky130_fd_sc_hd__decap_3
XFILLER_3_62 VGND VGND VPWR VPWR sky130_fd_sc_hd__decap_3
XFILLER_22_49 VGND VGND VPWR VPWR sky130_fd_sc_hd__decap_3
XFILLER_0_9 VGND VGND VPWR VPWR sky130_fd_sc_hd__decap_3
XPHY_EDGE_ROW_29_Right_29 VGND VGND VPWR VPWR sky130_fd_sc_hd__decap_3
XFILLER_10_197 VGND VGND VPWR VPWR sky130_fd_sc_hd__fill_1
XFILLER_3_116 VGND VGND VPWR VPWR sky130_fd_sc_hd__decap_3
XPHY_EDGE_ROW_4_Left_41 VGND VGND VPWR VPWR sky130_fd_sc_hd__decap_3
Xmax_cap119 input6/X VGND VGND VPWR VPWR _726_/B sky130_fd_sc_hd__buf_6
XFILLER_23_81 VGND VGND VPWR VPWR sky130_fd_sc_hd__decap_3
XFILLER_2_171 VGND VGND VPWR VPWR sky130_fd_sc_hd__decap_3
XFILLER_9_94 VGND VGND VPWR VPWR sky130_fd_sc_hd__decap_3
XPHY_EDGE_ROW_30_Left_67 VGND VGND VPWR VPWR sky130_fd_sc_hd__decap_3
XFILLER_5_19 VGND VGND VPWR VPWR sky130_fd_sc_hd__decap_3
X_685_ _692_/A _692_/B _691_/B VGND VGND VPWR VPWR _685_/X sky130_fd_sc_hd__a21o_2
XTAP_TAPCELL_ROW_5_95 VGND VPWR sky130_fd_sc_hd__tapvpwrvgnd_1
Xload_slew111 _694_/A VGND VGND VPWR VPWR _709_/A sky130_fd_sc_hd__buf_6
XFILLER_30_38 VGND VGND VPWR VPWR sky130_fd_sc_hd__decap_3
XFILLER_29_178 VGND VGND VPWR VPWR sky130_fd_sc_hd__decap_3
XFILLER_29_156 VGND VGND VPWR VPWR sky130_fd_sc_hd__decap_3
X_470_ _471_/A _468_/X _469_/X VGND VGND VPWR VPWR _470_/Y sky130_fd_sc_hd__a21oi_2
XFILLER_20_82 VGND VGND VPWR VPWR sky130_fd_sc_hd__fill_2
X_599_ _701_/A _713_/A _716_/B _596_/A VGND VGND VPWR VPWR _599_/Y sky130_fd_sc_hd__a211oi_2
X_668_ _728_/A VGND VGND VPWR VPWR _668_/Y sky130_fd_sc_hd__inv_2
X_737_ _737_/A _737_/B VGND VGND VPWR VPWR _740_/B sky130_fd_sc_hd__xnor2_2
XFILLER_25_38 VGND VGND VPWR VPWR sky130_fd_sc_hd__decap_3
Xrebuffer146 _739_/A VGND VGND VPWR VPWR _363_/A sky130_fd_sc_hd__buf_2
Xrebuffer135 _731_/A VGND VGND VPWR VPWR _730_/D sky130_fd_sc_hd__buf_2
Xrebuffer124 rebuffer167/X VGND VGND VPWR VPWR _476_/A sky130_fd_sc_hd__buf_4
XFILLER_1_214 VGND VGND VPWR VPWR sky130_fd_sc_hd__decap_3
X_522_ _520_/Y _521_/X _495_/Y VGND VGND VPWR VPWR _522_/Y sky130_fd_sc_hd__a21oi_2
X_453_ _468_/B _471_/A VGND VGND VPWR VPWR _464_/C sky130_fd_sc_hd__xnor2_2
X_384_ _586_/B _380_/X _381_/X _383_/Y VGND VGND VPWR VPWR _385_/B sky130_fd_sc_hd__a31o_2
Xoutput70 _640_/Y VGND VGND VPWR VPWR S[13] sky130_fd_sc_hd__dlymetal6s4s_1
XTAP_TAPCELL_ROW_2_85 VGND VPWR sky130_fd_sc_hd__tapvpwrvgnd_1
XPHY_EDGE_ROW_33_Left_70 VGND VGND VPWR VPWR sky130_fd_sc_hd__decap_3
XFILLER_31_92 VGND VGND VPWR VPWR sky130_fd_sc_hd__decap_3
Xoutput92 _587_/Y VGND VGND VPWR VPWR S[4] sky130_fd_sc_hd__buf_6
Xoutput81 _461_/Y VGND VGND VPWR VPWR S[23] sky130_fd_sc_hd__buf_6
XTAP_TAPCELL_ROW_18_143 VGND VPWR sky130_fd_sc_hd__tapvpwrvgnd_1
XFILLER_31_140 VGND VGND VPWR VPWR sky130_fd_sc_hd__decap_3
XFILLER_14_118 VGND VGND VPWR VPWR sky130_fd_sc_hd__decap_3
XTAP_TAPCELL_ROW_32_190 VGND VPWR sky130_fd_sc_hd__tapvpwrvgnd_1
XFILLER_22_195 VGND VGND VPWR VPWR sky130_fd_sc_hd__fill_1
XTAP_TAPCELL_ROW_9_111 VGND VPWR sky130_fd_sc_hd__tapvpwrvgnd_1
XFILLER_7_3 VGND VGND VPWR VPWR sky130_fd_sc_hd__decap_3
X_505_ _505_/A VGND VGND VPWR VPWR _506_/B sky130_fd_sc_hd__inv_2
X_436_ _436_/A _437_/B _436_/C VGND VGND VPWR VPWR _438_/B sky130_fd_sc_hd__or3_4
XFILLER_9_100 VGND VGND VPWR VPWR sky130_fd_sc_hd__decap_3
X_367_ _369_/B _369_/C _736_/B VGND VGND VPWR VPWR _367_/X sky130_fd_sc_hd__a21bo_4
XFILLER_9_166 VGND VGND VPWR VPWR sky130_fd_sc_hd__fill_2
XFILLER_9_122 VGND VGND VPWR VPWR sky130_fd_sc_hd__decap_3
XFILLER_3_41 VGND VGND VPWR VPWR sky130_fd_sc_hd__decap_3
XFILLER_3_96 VGND VGND VPWR VPWR sky130_fd_sc_hd__fill_1
Xfanout112 _521_/A VGND VGND VPWR VPWR _539_/A sky130_fd_sc_hd__clkdlybuf4s25_1
XFILLER_10_121 VGND VGND VPWR VPWR sky130_fd_sc_hd__decap_3
XFILLER_12_61 VGND VGND VPWR VPWR sky130_fd_sc_hd__fill_1
XFILLER_12_94 VGND VGND VPWR VPWR sky130_fd_sc_hd__decap_3
X_419_ _708_/Y _721_/X _725_/X _742_/B VGND VGND VPWR VPWR _631_/A sky130_fd_sc_hd__a31o_2
XFILLER_24_213 VGND VGND VPWR VPWR sky130_fd_sc_hd__decap_3
XFILLER_23_93 VGND VGND VPWR VPWR sky130_fd_sc_hd__decap_3
XFILLER_23_60 VGND VGND VPWR VPWR sky130_fd_sc_hd__decap_3
XFILLER_2_183 VGND VGND VPWR VPWR sky130_fd_sc_hd__decap_3
XFILLER_0_109 VGND VGND VPWR VPWR sky130_fd_sc_hd__decap_3
XFILLER_28_27 VGND VGND VPWR VPWR sky130_fd_sc_hd__fill_1
XFILLER_18_71 VGND VGND VPWR VPWR sky130_fd_sc_hd__decap_3
X_684_ _691_/B _684_/B VGND VGND VPWR VPWR _684_/Y sky130_fd_sc_hd__nor2_2
XTAP_TAPCELL_ROW_5_96 VGND VPWR sky130_fd_sc_hd__tapvpwrvgnd_1
XFILLER_22_3 VGND VGND VPWR VPWR sky130_fd_sc_hd__decap_3
XFILLER_4_212 VGND VGND VPWR VPWR sky130_fd_sc_hd__decap_3
X_736_ _736_/A _736_/B VGND VGND VPWR VPWR _740_/A sky130_fd_sc_hd__xnor2_2
XFILLER_29_92 VGND VGND VPWR VPWR sky130_fd_sc_hd__fill_1
X_598_ _701_/A _716_/A _716_/B _596_/A VGND VGND VPWR VPWR _598_/X sky130_fd_sc_hd__o211a_2
X_667_ _739_/A VGND VGND VPWR VPWR _667_/X sky130_fd_sc_hd__buf_6
XFILLER_28_190 VGND VGND VPWR VPWR sky130_fd_sc_hd__fill_1
XFILLER_6_85 VGND VGND VPWR VPWR sky130_fd_sc_hd__decap_3
XFILLER_26_116 VGND VGND VPWR VPWR sky130_fd_sc_hd__decap_3
XFILLER_34_182 VGND VGND VPWR VPWR sky130_fd_sc_hd__decap_3
XFILLER_34_160 VGND VGND VPWR VPWR sky130_fd_sc_hd__fill_1
Xrebuffer136 _734_/X VGND VGND VPWR VPWR _739_/C sky130_fd_sc_hd__buf_2
Xrebuffer125 rebuffer167/X VGND VGND VPWR VPWR _549_/A2 sky130_fd_sc_hd__buf_2
XFILLER_17_105 VGND VGND VPWR VPWR sky130_fd_sc_hd__decap_3
XFILLER_17_116 VGND VGND VPWR VPWR sky130_fd_sc_hd__decap_3
XFILLER_17_149 VGND VGND VPWR VPWR sky130_fd_sc_hd__decap_3
X_521_ _521_/A _521_/B _521_/C VGND VGND VPWR VPWR _521_/X sky130_fd_sc_hd__or3_2
X_452_ _452_/A _452_/B VGND VGND VPWR VPWR _452_/Y sky130_fd_sc_hd__xnor2_2
X_383_ _380_/X _382_/X _457_/A VGND VGND VPWR VPWR _383_/Y sky130_fd_sc_hd__a21oi_2
XFILLER_25_193 VGND VGND VPWR VPWR sky130_fd_sc_hd__fill_2
Xoutput93 _594_/X VGND VGND VPWR VPWR S[5] sky130_fd_sc_hd__buf_6
Xoutput82 _479_/Y VGND VGND VPWR VPWR S[24] sky130_fd_sc_hd__buf_6
Xoutput71 _649_/Y VGND VGND VPWR VPWR S[14] sky130_fd_sc_hd__buf_6
XTAP_TAPCELL_ROW_2_86 VGND VPWR sky130_fd_sc_hd__tapvpwrvgnd_1
X_719_ _701_/A _717_/X _718_/X VGND VGND VPWR VPWR _719_/Y sky130_fd_sc_hd__a21oi_2
XFILLER_16_160 VGND VGND VPWR VPWR sky130_fd_sc_hd__decap_3
XFILLER_31_152 VGND VGND VPWR VPWR sky130_fd_sc_hd__decap_3
XFILLER_23_119 VGND VGND VPWR VPWR sky130_fd_sc_hd__decap_3
XFILLER_23_108 VGND VGND VPWR VPWR sky130_fd_sc_hd__decap_3
XTAP_TAPCELL_ROW_32_191 VGND VPWR sky130_fd_sc_hd__tapvpwrvgnd_1
XFILLER_22_141 VGND VGND VPWR VPWR sky130_fd_sc_hd__fill_1
XFILLER_13_152 VGND VGND VPWR VPWR sky130_fd_sc_hd__decap_3
X_504_ _504_/A _505_/A _506_/C _506_/A VGND VGND VPWR VPWR _508_/C sky130_fd_sc_hd__and4_4
X_435_ _434_/Y _440_/A _437_/C VGND VGND VPWR VPWR _438_/A sky130_fd_sc_hd__mux2_4
X_366_ _364_/X _363_/Y _365_/Y VGND VGND VPWR VPWR _369_/B sky130_fd_sc_hd__a21o_4
XFILLER_9_134 VGND VGND VPWR VPWR sky130_fd_sc_hd__fill_1
XFILLER_26_60 VGND VGND VPWR VPWR sky130_fd_sc_hd__decap_3
XFILLER_3_53 VGND VGND VPWR VPWR sky130_fd_sc_hd__decap_3
XFILLER_36_200 VGND VGND VPWR VPWR sky130_fd_sc_hd__decap_3
XFILLER_22_29 VGND VGND VPWR VPWR sky130_fd_sc_hd__decap_3
XFILLER_10_100 VGND VGND VPWR VPWR sky130_fd_sc_hd__decap_3
XFILLER_10_144 VGND VGND VPWR VPWR sky130_fd_sc_hd__decap_3
XTAP_TAPCELL_ROW_20_150 VGND VPWR sky130_fd_sc_hd__tapvpwrvgnd_1
XFILLER_6_137 VGND VGND VPWR VPWR sky130_fd_sc_hd__decap_3
X_418_ _418_/A _418_/B _418_/C VGND VGND VPWR VPWR _420_/A sky130_fd_sc_hd__and3_4
XFILLER_33_39 VGND VGND VPWR VPWR sky130_fd_sc_hd__decap_3
XFILLER_17_6 VGND VGND VPWR VPWR sky130_fd_sc_hd__decap_3
XFILLER_2_195 VGND VGND VPWR VPWR sky130_fd_sc_hd__fill_1
XFILLER_9_85 VGND VGND VPWR VPWR sky130_fd_sc_hd__decap_3
XFILLER_9_63 VGND VGND VPWR VPWR sky130_fd_sc_hd__decap_3
XFILLER_9_52 VGND VGND VPWR VPWR sky130_fd_sc_hd__decap_3
XFILLER_18_83 VGND VGND VPWR VPWR sky130_fd_sc_hd__fill_1
X_683_ _691_/B _684_/B _691_/A VGND VGND VPWR VPWR _683_/Y sky130_fd_sc_hd__a21boi_2
XTAP_TAPCELL_ROW_5_97 VGND VPWR sky130_fd_sc_hd__tapvpwrvgnd_1
Xload_slew113 _539_/A VGND VGND VPWR VPWR _661_/A sky130_fd_sc_hd__clkbuf_4
XFILLER_30_29 VGND VGND VPWR VPWR sky130_fd_sc_hd__decap_3
XFILLER_29_125 VGND VGND VPWR VPWR sky130_fd_sc_hd__decap_3
XFILLER_20_62 VGND VGND VPWR VPWR sky130_fd_sc_hd__fill_1
XFILLER_20_40 VGND VGND VPWR VPWR sky130_fd_sc_hd__decap_3
X_735_ _739_/A _739_/B _739_/C VGND VGND VPWR VPWR _735_/X sky130_fd_sc_hd__and3_2
XFILLER_29_60 VGND VGND VPWR VPWR sky130_fd_sc_hd__decap_3
X_597_ _713_/A _592_/B _595_/X _596_/Y VGND VGND VPWR VPWR _597_/X sky130_fd_sc_hd__a22o_2
X_666_ _666_/A VGND VGND VPWR VPWR _739_/A sky130_fd_sc_hd__inv_8
XFILLER_26_128 VGND VGND VPWR VPWR sky130_fd_sc_hd__decap_3
XFILLER_25_29 VGND VGND VPWR VPWR sky130_fd_sc_hd__decap_3
Xrebuffer137 _459_/S VGND VGND VPWR VPWR _452_/A sky130_fd_sc_hd__buf_4
Xrebuffer126 _391_/B VGND VGND VPWR VPWR _413_/A sky130_fd_sc_hd__buf_6
XFILLER_34_194 VGND VGND VPWR VPWR sky130_fd_sc_hd__fill_2
Xrebuffer148 _611_/X VGND VGND VPWR VPWR _614_/A sky130_fd_sc_hd__buf_2
XFILLER_1_205 VGND VGND VPWR VPWR sky130_fd_sc_hd__decap_3
X_520_ _521_/A _521_/B _521_/C VGND VGND VPWR VPWR _520_/Y sky130_fd_sc_hd__nand3_2
XFILLER_15_84 VGND VGND VPWR VPWR sky130_fd_sc_hd__fill_2
XFILLER_17_128 VGND VGND VPWR VPWR sky130_fd_sc_hd__decap_3
X_451_ _468_/A _464_/B VGND VGND VPWR VPWR _452_/B sky130_fd_sc_hd__xnor2_2
X_382_ _380_/A _380_/B _372_/A VGND VGND VPWR VPWR _382_/X sky130_fd_sc_hd__a21o_2
XFILLER_25_150 VGND VGND VPWR VPWR sky130_fd_sc_hd__decap_3
XFILLER_15_95 VGND VGND VPWR VPWR sky130_fd_sc_hd__decap_3
XFILLER_31_50 VGND VGND VPWR VPWR sky130_fd_sc_hd__decap_3
Xoutput94 _604_/Y VGND VGND VPWR VPWR S[6] sky130_fd_sc_hd__buf_6
Xoutput83 _486_/Y VGND VGND VPWR VPWR S[25] sky130_fd_sc_hd__buf_6
Xoutput72 _655_/Y VGND VGND VPWR VPWR S[15] sky130_fd_sc_hd__buf_6
XTAP_TAPCELL_ROW_2_87 VGND VPWR sky130_fd_sc_hd__tapvpwrvgnd_1
X_649_ _649_/A _649_/B VGND VGND VPWR VPWR _649_/Y sky130_fd_sc_hd__xnor2_2
X_718_ _713_/A _716_/B _703_/B _569_/A VGND VGND VPWR VPWR _718_/X sky130_fd_sc_hd__a31o_2
XFILLER_14_109 VGND VGND VPWR VPWR sky130_fd_sc_hd__decap_3
XFILLER_22_131 VGND VGND VPWR VPWR sky130_fd_sc_hd__decap_3
XTAP_TAPCELL_ROW_32_192 VGND VPWR sky130_fd_sc_hd__tapvpwrvgnd_1
XFILLER_22_175 VGND VGND VPWR VPWR sky130_fd_sc_hd__decap_3
X_503_ _506_/C _497_/B _502_/Y _505_/A VGND VGND VPWR VPWR _508_/A sky130_fd_sc_hd__a211oi_2
XFILLER_13_131 VGND VGND VPWR VPWR sky130_fd_sc_hd__decap_3
XFILLER_13_164 VGND VGND VPWR VPWR sky130_fd_sc_hd__decap_3
XFILLER_13_175 VGND VGND VPWR VPWR sky130_fd_sc_hd__decap_3
X_434_ _434_/A _437_/B VGND VGND VPWR VPWR _434_/Y sky130_fd_sc_hd__nand2_2
X_365_ _737_/B VGND VGND VPWR VPWR _365_/Y sky130_fd_sc_hd__inv_2
XFILLER_9_157 VGND VGND VPWR VPWR sky130_fd_sc_hd__decap_3
XFILLER_9_113 VGND VGND VPWR VPWR sky130_fd_sc_hd__decap_3
XFILLER_3_87 VGND VGND VPWR VPWR sky130_fd_sc_hd__decap_3
XFILLER_3_65 VGND VGND VPWR VPWR sky130_fd_sc_hd__fill_1
XFILLER_36_212 VGND VGND VPWR VPWR sky130_fd_sc_hd__decap_3
Xfanout103 fanout107/X VGND VGND VPWR VPWR _373_/A sky130_fd_sc_hd__buf_4
Xfanout114 _679_/C1 VGND VGND VPWR VPWR _664_/A sky130_fd_sc_hd__clkbuf_2
XFILLER_10_112 VGND VGND VPWR VPWR sky130_fd_sc_hd__decap_3
XFILLER_18_201 VGND VGND VPWR VPWR sky130_fd_sc_hd__fill_1
XPHY_EDGE_ROW_16_Right_16 VGND VGND VPWR VPWR sky130_fd_sc_hd__decap_3
X_417_ _417_/A _417_/B VGND VGND VPWR VPWR _418_/A sky130_fd_sc_hd__or2_4
XPHY_EDGE_ROW_25_Right_25 VGND VGND VPWR VPWR sky130_fd_sc_hd__decap_3
XPHY_EDGE_ROW_34_Right_34 VGND VGND VPWR VPWR sky130_fd_sc_hd__decap_3
XFILLER_3_119 VGND VGND VPWR VPWR sky130_fd_sc_hd__decap_3
XFILLER_23_84 VGND VGND VPWR VPWR sky130_fd_sc_hd__decap_3
XFILLER_2_174 VGND VGND VPWR VPWR sky130_fd_sc_hd__decap_3
XFILLER_2_141 VGND VGND VPWR VPWR sky130_fd_sc_hd__fill_2
XFILLER_9_97 VGND VGND VPWR VPWR sky130_fd_sc_hd__decap_3
XFILLER_28_29 VGND VGND VPWR VPWR sky130_fd_sc_hd__decap_3
XPHY_EDGE_ROW_8_Left_45 VGND VGND VPWR VPWR sky130_fd_sc_hd__decap_3
XFILLER_18_62 VGND VGND VPWR VPWR sky130_fd_sc_hd__decap_3
X_682_ _692_/A _692_/B VGND VGND VPWR VPWR _684_/B sky130_fd_sc_hd__or2b_2
XFILLER_34_61 VGND VGND VPWR VPWR sky130_fd_sc_hd__fill_2
XPHY_EDGE_ROW_2_Right_2 VGND VGND VPWR VPWR sky130_fd_sc_hd__decap_3
XFILLER_29_159 VGND VGND VPWR VPWR sky130_fd_sc_hd__fill_2
X_665_ _727_/A _665_/B VGND VGND VPWR VPWR _665_/X sky130_fd_sc_hd__and2_2
X_734_ _734_/A _734_/B VGND VGND VPWR VPWR _734_/X sky130_fd_sc_hd__xor2_4
XFILLER_29_83 VGND VGND VPWR VPWR sky130_fd_sc_hd__decap_3
XFILLER_29_72 VGND VGND VPWR VPWR sky130_fd_sc_hd__fill_2
XFILLER_28_181 VGND VGND VPWR VPWR sky130_fd_sc_hd__decap_3
X_596_ _596_/A _701_/A VGND VGND VPWR VPWR _596_/Y sky130_fd_sc_hd__nand2_2
Xrebuffer149 _623_/S VGND VGND VPWR VPWR _618_/A sky130_fd_sc_hd__buf_6
Xrebuffer138 _731_/B VGND VGND VPWR VPWR _730_/B sky130_fd_sc_hd__buf_2
Xrebuffer127 _726_/B VGND VGND VPWR VPWR _650_/A sky130_fd_sc_hd__buf_2
X_450_ _458_/B _455_/B VGND VGND VPWR VPWR _464_/B sky130_fd_sc_hd__xnor2_2
X_381_ _380_/A _380_/B _372_/A VGND VGND VPWR VPWR _381_/X sky130_fd_sc_hd__a21bo_2
XFILLER_31_95 VGND VGND VPWR VPWR sky130_fd_sc_hd__decap_3
Xoutput95 _610_/Y VGND VGND VPWR VPWR S[7] sky130_fd_sc_hd__buf_6
Xoutput84 _500_/Y VGND VGND VPWR VPWR S[26] sky130_fd_sc_hd__buf_6
Xoutput73 _374_/Y VGND VGND VPWR VPWR S[16] sky130_fd_sc_hd__buf_6
XFILLER_16_151 VGND VGND VPWR VPWR sky130_fd_sc_hd__decap_3
X_648_ _648_/A _731_/D VGND VGND VPWR VPWR _649_/B sky130_fd_sc_hd__xnor2_2
X_717_ _716_/B _703_/B _713_/A VGND VGND VPWR VPWR _717_/X sky130_fd_sc_hd__a21o_2
X_579_ _692_/B _581_/B _692_/A VGND VGND VPWR VPWR _583_/A sky130_fd_sc_hd__nor3b_2
XFILLER_31_176 VGND VGND VPWR VPWR sky130_fd_sc_hd__decap_3
XFILLER_31_143 VGND VGND VPWR VPWR sky130_fd_sc_hd__decap_3
XFILLER_36_29 VGND VGND VPWR VPWR sky130_fd_sc_hd__decap_3
XFILLER_22_110 VGND VGND VPWR VPWR sky130_fd_sc_hd__decap_3
XFILLER_7_6 VGND VGND VPWR VPWR sky130_fd_sc_hd__fill_2
X_502_ _504_/A VGND VGND VPWR VPWR _502_/Y sky130_fd_sc_hd__inv_2
X_433_ _447_/B _445_/A VGND VGND VPWR VPWR _441_/B sky130_fd_sc_hd__xnor2_2
XFILLER_26_51 VGND VGND VPWR VPWR sky130_fd_sc_hd__decap_3
XFILLER_13_143 VGND VGND VPWR VPWR sky130_fd_sc_hd__decap_3
XFILLER_13_187 VGND VGND VPWR VPWR sky130_fd_sc_hd__decap_3
X_364_ _734_/X _737_/A _739_/B _739_/A VGND VGND VPWR VPWR _364_/X sky130_fd_sc_hd__or4_4
XTAP_TAPCELL_ROW_23_160 VGND VPWR sky130_fd_sc_hd__tapvpwrvgnd_1
XPHY_EDGE_ROW_21_Left_58 VGND VGND VPWR VPWR sky130_fd_sc_hd__decap_3
XFILLER_9_169 VGND VGND VPWR VPWR sky130_fd_sc_hd__fill_2
XFILLER_9_125 VGND VGND VPWR VPWR sky130_fd_sc_hd__decap_3
XFILLER_9_103 VGND VGND VPWR VPWR sky130_fd_sc_hd__decap_3
XFILLER_3_44 VGND VGND VPWR VPWR sky130_fd_sc_hd__fill_1
XFILLER_10_124 VGND VGND VPWR VPWR sky130_fd_sc_hd__decap_3
XTAP_TAPCELL_ROW_12_119 VGND VPWR sky130_fd_sc_hd__tapvpwrvgnd_1
XFILLER_12_75 VGND VGND VPWR VPWR sky130_fd_sc_hd__decap_3
XFILLER_12_97 VGND VGND VPWR VPWR sky130_fd_sc_hd__decap_3
XFILLER_5_3 VGND VGND VPWR VPWR sky130_fd_sc_hd__decap_3
X_416_ _413_/Y _414_/X _417_/B _417_/A VGND VGND VPWR VPWR _418_/B sky130_fd_sc_hd__a22o_4
XFILLER_5_172 VGND VGND VPWR VPWR sky130_fd_sc_hd__fill_2
XFILLER_24_216 VGND VGND VPWR VPWR sky130_fd_sc_hd__fill_1
XFILLER_23_96 VGND VGND VPWR VPWR sky130_fd_sc_hd__decap_3
XFILLER_23_63 VGND VGND VPWR VPWR sky130_fd_sc_hd__decap_3
XFILLER_2_186 VGND VGND VPWR VPWR sky130_fd_sc_hd__decap_3
XFILLER_0_12 VGND VGND VPWR VPWR sky130_fd_sc_hd__decap_3
XFILLER_9_21 VGND VGND VPWR VPWR sky130_fd_sc_hd__fill_2
XPHY_EDGE_ROW_24_Left_61 VGND VGND VPWR VPWR sky130_fd_sc_hd__decap_3
XFILLER_28_19 VGND VGND VPWR VPWR sky130_fd_sc_hd__decap_3
XFILLER_18_74 VGND VGND VPWR VPWR sky130_fd_sc_hd__decap_3
XFILLER_18_85 VGND VGND VPWR VPWR sky130_fd_sc_hd__decap_3
X_681_ _665_/X _676_/X _680_/X VGND VGND VPWR VPWR _681_/Y sky130_fd_sc_hd__o21bai_2
Xload_slew115 _664_/A VGND VGND VPWR VPWR _521_/A sky130_fd_sc_hd__buf_4
Xload_slew104 _373_/A VGND VGND VPWR VPWR _391_/B sky130_fd_sc_hd__buf_6
XFILLER_4_215 VGND VGND VPWR VPWR sky130_fd_sc_hd__fill_2
X_595_ _596_/A _701_/A VGND VGND VPWR VPWR _595_/X sky130_fd_sc_hd__or2_2
X_664_ _664_/A _727_/B VGND VGND VPWR VPWR _665_/B sky130_fd_sc_hd__xor2_2
X_733_ _733_/A _733_/B VGND VGND VPWR VPWR _739_/B sky130_fd_sc_hd__xor2_4
XFILLER_6_88 VGND VGND VPWR VPWR sky130_fd_sc_hd__decap_3
XFILLER_26_119 VGND VGND VPWR VPWR sky130_fd_sc_hd__decap_3
XFILLER_34_141 VGND VGND VPWR VPWR sky130_fd_sc_hd__fill_2
XFILLER_19_182 VGND VGND VPWR VPWR sky130_fd_sc_hd__decap_3
XFILLER_19_160 VGND VGND VPWR VPWR sky130_fd_sc_hd__decap_3
Xrebuffer139 fanout105/X VGND VGND VPWR VPWR _506_/D sky130_fd_sc_hd__buf_2
Xrebuffer128 _506_/A VGND VGND VPWR VPWR _497_/B sky130_fd_sc_hd__buf_2
XFILLER_17_108 VGND VGND VPWR VPWR sky130_fd_sc_hd__decap_3
XFILLER_17_119 VGND VGND VPWR VPWR sky130_fd_sc_hd__decap_3
XFILLER_15_20 VGND VGND VPWR VPWR sky130_fd_sc_hd__decap_3
X_380_ _380_/A _380_/B VGND VGND VPWR VPWR _380_/X sky130_fd_sc_hd__or2_2
XFILLER_31_41 VGND VGND VPWR VPWR sky130_fd_sc_hd__decap_3
X_716_ _716_/A _716_/B _703_/B VGND VGND VPWR VPWR _716_/X sky130_fd_sc_hd__or3b_2
Xoutput96 _614_/Y VGND VGND VPWR VPWR S[8] sky130_fd_sc_hd__buf_6
Xoutput85 _509_/Y VGND VGND VPWR VPWR S[27] sky130_fd_sc_hd__buf_6
Xoutput74 _385_/X VGND VGND VPWR VPWR S[17] sky130_fd_sc_hd__clkbuf_2
XFILLER_16_163 VGND VGND VPWR VPWR sky130_fd_sc_hd__decap_3
XFILLER_16_185 VGND VGND VPWR VPWR sky130_fd_sc_hd__decap_3
X_578_ _578_/A _581_/B VGND VGND VPWR VPWR _578_/Y sky130_fd_sc_hd__xnor2_2
X_647_ _635_/X _643_/X _646_/X _645_/X VGND VGND VPWR VPWR _647_/Y sky130_fd_sc_hd__a22oi_2
XFILLER_31_122 VGND VGND VPWR VPWR sky130_fd_sc_hd__decap_3
XFILLER_31_155 VGND VGND VPWR VPWR sky130_fd_sc_hd__decap_3
.ends
