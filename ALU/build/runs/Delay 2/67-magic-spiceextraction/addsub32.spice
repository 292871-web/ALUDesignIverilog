* NGSPICE file created from addsub32.ext - technology: sky130A

* Black-box entry subcircuit for sky130_fd_sc_hd__decap_3 abstract view
.subckt sky130_fd_sc_hd__decap_3 VGND VNB VPB VPWR
.ends

* Black-box entry subcircuit for sky130_fd_sc_hd__and2_4 abstract view
.subckt sky130_fd_sc_hd__and2_4 A B VGND VNB VPB VPWR X
.ends

* Black-box entry subcircuit for sky130_fd_sc_hd__o21bai_4 abstract view
.subckt sky130_fd_sc_hd__o21bai_4 A1 A2 B1_N VGND VNB VPB VPWR Y
.ends

* Black-box entry subcircuit for sky130_fd_sc_hd__tapvpwrvgnd_1 abstract view
.subckt sky130_fd_sc_hd__tapvpwrvgnd_1 VGND VPWR
.ends

* Black-box entry subcircuit for sky130_fd_sc_hd__fill_2 abstract view
.subckt sky130_fd_sc_hd__fill_2 VGND VNB VPB VPWR
.ends

* Black-box entry subcircuit for sky130_fd_sc_hd__nand2b_4 abstract view
.subckt sky130_fd_sc_hd__nand2b_4 A_N B VGND VNB VPB VPWR Y
.ends

* Black-box entry subcircuit for sky130_fd_sc_hd__buf_8 abstract view
.subckt sky130_fd_sc_hd__buf_8 A VGND VNB VPB VPWR X
.ends

* Black-box entry subcircuit for sky130_fd_sc_hd__buf_4 abstract view
.subckt sky130_fd_sc_hd__buf_4 A VGND VNB VPB VPWR X
.ends

* Black-box entry subcircuit for sky130_fd_sc_hd__fill_1 abstract view
.subckt sky130_fd_sc_hd__fill_1 VGND VNB VPB VPWR
.ends

* Black-box entry subcircuit for sky130_fd_sc_hd__o211ai_4 abstract view
.subckt sky130_fd_sc_hd__o211ai_4 A1 A2 B1 C1 VGND VNB VPB VPWR Y
.ends

* Black-box entry subcircuit for sky130_fd_sc_hd__nor2_2 abstract view
.subckt sky130_fd_sc_hd__nor2_2 A B VGND VNB VPB VPWR Y
.ends

* Black-box entry subcircuit for sky130_fd_sc_hd__and2_2 abstract view
.subckt sky130_fd_sc_hd__and2_2 A B VGND VNB VPB VPWR X
.ends

* Black-box entry subcircuit for sky130_fd_sc_hd__or3b_2 abstract view
.subckt sky130_fd_sc_hd__or3b_2 A B C_N VGND VNB VPB VPWR X
.ends

* Black-box entry subcircuit for sky130_fd_sc_hd__inv_2 abstract view
.subckt sky130_fd_sc_hd__inv_2 A VGND VNB VPB VPWR Y
.ends

* Black-box entry subcircuit for sky130_fd_sc_hd__buf_2 abstract view
.subckt sky130_fd_sc_hd__buf_2 A VGND VNB VPB VPWR X
.ends

* Black-box entry subcircuit for sky130_fd_sc_hd__buf_6 abstract view
.subckt sky130_fd_sc_hd__buf_6 A VGND VNB VPB VPWR X
.ends

* Black-box entry subcircuit for sky130_fd_sc_hd__o21ai_2 abstract view
.subckt sky130_fd_sc_hd__o21ai_2 A1 A2 B1 VGND VNB VPB VPWR Y
.ends

* Black-box entry subcircuit for sky130_fd_sc_hd__clkbuf_2 abstract view
.subckt sky130_fd_sc_hd__clkbuf_2 A VGND VNB VPB VPWR X
.ends

* Black-box entry subcircuit for sky130_fd_sc_hd__xor2_2 abstract view
.subckt sky130_fd_sc_hd__xor2_2 A B VGND VNB VPB VPWR X
.ends

* Black-box entry subcircuit for sky130_fd_sc_hd__o2bb2ai_2 abstract view
.subckt sky130_fd_sc_hd__o2bb2ai_2 A1_N A2_N B1 B2 VGND VNB VPB VPWR Y
.ends

* Black-box entry subcircuit for sky130_fd_sc_hd__nand3_2 abstract view
.subckt sky130_fd_sc_hd__nand3_2 A B C VGND VNB VPB VPWR Y
.ends

* Black-box entry subcircuit for sky130_fd_sc_hd__o22ai_2 abstract view
.subckt sky130_fd_sc_hd__o22ai_2 A1 A2 B1 B2 VGND VNB VPB VPWR Y
.ends

* Black-box entry subcircuit for sky130_fd_sc_hd__o211a_2 abstract view
.subckt sky130_fd_sc_hd__o211a_2 A1 A2 B1 C1 VGND VNB VPB VPWR X
.ends

* Black-box entry subcircuit for sky130_fd_sc_hd__a22oi_2 abstract view
.subckt sky130_fd_sc_hd__a22oi_2 A1 A2 B1 B2 VGND VNB VPB VPWR Y
.ends

* Black-box entry subcircuit for sky130_fd_sc_hd__nand3b_4 abstract view
.subckt sky130_fd_sc_hd__nand3b_4 A_N B C VGND VNB VPB VPWR Y
.ends

* Black-box entry subcircuit for sky130_fd_sc_hd__clkbuf_4 abstract view
.subckt sky130_fd_sc_hd__clkbuf_4 A VGND VNB VPB VPWR X
.ends

* Black-box entry subcircuit for sky130_fd_sc_hd__o22a_2 abstract view
.subckt sky130_fd_sc_hd__o22a_2 A1 A2 B1 B2 VGND VNB VPB VPWR X
.ends

* Black-box entry subcircuit for sky130_fd_sc_hd__nand4_4 abstract view
.subckt sky130_fd_sc_hd__nand4_4 A B C D VGND VNB VPB VPWR Y
.ends

* Black-box entry subcircuit for sky130_fd_sc_hd__nand3b_2 abstract view
.subckt sky130_fd_sc_hd__nand3b_2 A_N B C VGND VNB VPB VPWR Y
.ends

* Black-box entry subcircuit for sky130_fd_sc_hd__xnor2_2 abstract view
.subckt sky130_fd_sc_hd__xnor2_2 A B VGND VNB VPB VPWR Y
.ends

* Black-box entry subcircuit for sky130_fd_sc_hd__nand2_2 abstract view
.subckt sky130_fd_sc_hd__nand2_2 A B VGND VNB VPB VPWR Y
.ends

* Black-box entry subcircuit for sky130_fd_sc_hd__clkdlybuf4s25_1 abstract view
.subckt sky130_fd_sc_hd__clkdlybuf4s25_1 A VGND VNB VPB VPWR X
.ends

* Black-box entry subcircuit for sky130_fd_sc_hd__or2_2 abstract view
.subckt sky130_fd_sc_hd__or2_2 A B VGND VNB VPB VPWR X
.ends

* Black-box entry subcircuit for sky130_fd_sc_hd__o21bai_2 abstract view
.subckt sky130_fd_sc_hd__o21bai_2 A1 A2 B1_N VGND VNB VPB VPWR Y
.ends

* Black-box entry subcircuit for sky130_fd_sc_hd__mux2_1 abstract view
.subckt sky130_fd_sc_hd__mux2_1 A0 A1 S VGND VNB VPB VPWR X
.ends

* Black-box entry subcircuit for sky130_fd_sc_hd__inv_6 abstract view
.subckt sky130_fd_sc_hd__inv_6 A VGND VNB VPB VPWR Y
.ends

* Black-box entry subcircuit for sky130_fd_sc_hd__nand2b_2 abstract view
.subckt sky130_fd_sc_hd__nand2b_2 A_N B VGND VNB VPB VPWR Y
.ends

* Black-box entry subcircuit for sky130_fd_sc_hd__nand4_2 abstract view
.subckt sky130_fd_sc_hd__nand4_2 A B C D VGND VNB VPB VPWR Y
.ends

* Black-box entry subcircuit for sky130_fd_sc_hd__and3_2 abstract view
.subckt sky130_fd_sc_hd__and3_2 A B C VGND VNB VPB VPWR X
.ends

* Black-box entry subcircuit for sky130_fd_sc_hd__and4_4 abstract view
.subckt sky130_fd_sc_hd__and4_4 A B C D VGND VNB VPB VPWR X
.ends

* Black-box entry subcircuit for sky130_fd_sc_hd__o21ba_2 abstract view
.subckt sky130_fd_sc_hd__o21ba_2 A1 A2 B1_N VGND VNB VPB VPWR X
.ends

* Black-box entry subcircuit for sky130_fd_sc_hd__dlymetal6s2s_1 abstract view
.subckt sky130_fd_sc_hd__dlymetal6s2s_1 A VGND VNB VPB VPWR X
.ends

* Black-box entry subcircuit for sky130_fd_sc_hd__a21oi_2 abstract view
.subckt sky130_fd_sc_hd__a21oi_2 A1 A2 B1 VGND VNB VPB VPWR Y
.ends

* Black-box entry subcircuit for sky130_fd_sc_hd__a21o_2 abstract view
.subckt sky130_fd_sc_hd__a21o_2 A1 A2 B1 VGND VNB VPB VPWR X
.ends

* Black-box entry subcircuit for sky130_fd_sc_hd__a22oi_4 abstract view
.subckt sky130_fd_sc_hd__a22oi_4 A1 A2 B1 B2 VGND VNB VPB VPWR Y
.ends

* Black-box entry subcircuit for sky130_fd_sc_hd__o21ai_4 abstract view
.subckt sky130_fd_sc_hd__o21ai_4 A1 A2 B1 VGND VNB VPB VPWR Y
.ends

* Black-box entry subcircuit for sky130_fd_sc_hd__a21boi_2 abstract view
.subckt sky130_fd_sc_hd__a21boi_2 A1 A2 B1_N VGND VNB VPB VPWR Y
.ends

* Black-box entry subcircuit for sky130_fd_sc_hd__and2b_2 abstract view
.subckt sky130_fd_sc_hd__and2b_2 A_N B VGND VNB VPB VPWR X
.ends

* Black-box entry subcircuit for sky130_fd_sc_hd__dlymetal6s4s_1 abstract view
.subckt sky130_fd_sc_hd__dlymetal6s4s_1 A VGND VNB VPB VPWR X
.ends

* Black-box entry subcircuit for sky130_fd_sc_hd__o221a_2 abstract view
.subckt sky130_fd_sc_hd__o221a_2 A1 A2 B1 B2 C1 VGND VNB VPB VPWR X
.ends

* Black-box entry subcircuit for sky130_fd_sc_hd__or3_4 abstract view
.subckt sky130_fd_sc_hd__or3_4 A B C VGND VNB VPB VPWR X
.ends

* Black-box entry subcircuit for sky130_fd_sc_hd__o31ai_4 abstract view
.subckt sky130_fd_sc_hd__o31ai_4 A1 A2 A3 B1 VGND VNB VPB VPWR Y
.ends

* Black-box entry subcircuit for sky130_fd_sc_hd__nand2_4 abstract view
.subckt sky130_fd_sc_hd__nand2_4 A B VGND VNB VPB VPWR Y
.ends

* Black-box entry subcircuit for sky130_fd_sc_hd__o21a_2 abstract view
.subckt sky130_fd_sc_hd__o21a_2 A1 A2 B1 VGND VNB VPB VPWR X
.ends

* Black-box entry subcircuit for sky130_fd_sc_hd__o22ai_4 abstract view
.subckt sky130_fd_sc_hd__o22ai_4 A1 A2 B1 B2 VGND VNB VPB VPWR Y
.ends

* Black-box entry subcircuit for sky130_fd_sc_hd__nand3_4 abstract view
.subckt sky130_fd_sc_hd__nand3_4 A B C VGND VNB VPB VPWR Y
.ends

* Black-box entry subcircuit for sky130_fd_sc_hd__nor2_4 abstract view
.subckt sky130_fd_sc_hd__nor2_4 A B VGND VNB VPB VPWR Y
.ends

* Black-box entry subcircuit for sky130_fd_sc_hd__and3b_2 abstract view
.subckt sky130_fd_sc_hd__and3b_2 A_N B C VGND VNB VPB VPWR X
.ends

* Black-box entry subcircuit for sky130_fd_sc_hd__nor2b_2 abstract view
.subckt sky130_fd_sc_hd__nor2b_2 A B_N VGND VNB VPB VPWR Y
.ends

* Black-box entry subcircuit for sky130_fd_sc_hd__a2bb2oi_2 abstract view
.subckt sky130_fd_sc_hd__a2bb2oi_2 A1_N A2_N B1 B2 VGND VNB VPB VPWR Y
.ends

* Black-box entry subcircuit for sky130_fd_sc_hd__a21bo_2 abstract view
.subckt sky130_fd_sc_hd__a21bo_2 A1 A2 B1_N VGND VNB VPB VPWR X
.ends

* Black-box entry subcircuit for sky130_fd_sc_hd__o2111ai_4 abstract view
.subckt sky130_fd_sc_hd__o2111ai_4 A1 A2 B1 C1 D1 VGND VNB VPB VPWR Y
.ends

* Black-box entry subcircuit for sky130_fd_sc_hd__nand4b_4 abstract view
.subckt sky130_fd_sc_hd__nand4b_4 A_N B C D VGND VNB VPB VPWR Y
.ends

* Black-box entry subcircuit for sky130_fd_sc_hd__a31oi_2 abstract view
.subckt sky130_fd_sc_hd__a31oi_2 A1 A2 A3 B1 VGND VNB VPB VPWR Y
.ends

* Black-box entry subcircuit for sky130_fd_sc_hd__o21a_4 abstract view
.subckt sky130_fd_sc_hd__o21a_4 A1 A2 B1 VGND VNB VPB VPWR X
.ends

* Black-box entry subcircuit for sky130_fd_sc_hd__a21o_4 abstract view
.subckt sky130_fd_sc_hd__a21o_4 A1 A2 B1 VGND VNB VPB VPWR X
.ends

* Black-box entry subcircuit for sky130_fd_sc_hd__a21oi_4 abstract view
.subckt sky130_fd_sc_hd__a21oi_4 A1 A2 B1 VGND VNB VPB VPWR Y
.ends

* Black-box entry subcircuit for sky130_fd_sc_hd__o2111a_2 abstract view
.subckt sky130_fd_sc_hd__o2111a_2 A1 A2 B1 C1 D1 VGND VNB VPB VPWR X
.ends

* Black-box entry subcircuit for sky130_fd_sc_hd__o2bb2a_2 abstract view
.subckt sky130_fd_sc_hd__o2bb2a_2 A1_N A2_N B1 B2 VGND VNB VPB VPWR X
.ends

* Black-box entry subcircuit for sky130_fd_sc_hd__o211ai_2 abstract view
.subckt sky130_fd_sc_hd__o211ai_2 A1 A2 B1 C1 VGND VNB VPB VPWR Y
.ends

* Black-box entry subcircuit for sky130_fd_sc_hd__or3b_4 abstract view
.subckt sky130_fd_sc_hd__or3b_4 A B C_N VGND VNB VPB VPWR X
.ends

* Black-box entry subcircuit for sky130_fd_sc_hd__nor3_4 abstract view
.subckt sky130_fd_sc_hd__nor3_4 A B C VGND VNB VPB VPWR Y
.ends

* Black-box entry subcircuit for sky130_fd_sc_hd__a32o_2 abstract view
.subckt sky130_fd_sc_hd__a32o_2 A1 A2 A3 B1 B2 VGND VNB VPB VPWR X
.ends

* Black-box entry subcircuit for sky130_fd_sc_hd__a31o_2 abstract view
.subckt sky130_fd_sc_hd__a31o_2 A1 A2 A3 B1 VGND VNB VPB VPWR X
.ends

* Black-box entry subcircuit for sky130_fd_sc_hd__a31o_4 abstract view
.subckt sky130_fd_sc_hd__a31o_4 A1 A2 A3 B1 VGND VNB VPB VPWR X
.ends

* Black-box entry subcircuit for sky130_fd_sc_hd__nor3b_2 abstract view
.subckt sky130_fd_sc_hd__nor3b_2 A B C_N VGND VNB VPB VPWR Y
.ends

* Black-box entry subcircuit for sky130_fd_sc_hd__and4_2 abstract view
.subckt sky130_fd_sc_hd__and4_2 A B C D VGND VNB VPB VPWR X
.ends

* Black-box entry subcircuit for sky130_fd_sc_hd__o2111a_4 abstract view
.subckt sky130_fd_sc_hd__o2111a_4 A1 A2 B1 C1 D1 VGND VNB VPB VPWR X
.ends

* Black-box entry subcircuit for sky130_fd_sc_hd__a211oi_2 abstract view
.subckt sky130_fd_sc_hd__a211oi_2 A1 A2 B1 C1 VGND VNB VPB VPWR Y
.ends

* Black-box entry subcircuit for sky130_fd_sc_hd__o2bb2ai_4 abstract view
.subckt sky130_fd_sc_hd__o2bb2ai_4 A1_N A2_N B1 B2 VGND VNB VPB VPWR Y
.ends

* Black-box entry subcircuit for sky130_fd_sc_hd__o2111ai_2 abstract view
.subckt sky130_fd_sc_hd__o2111ai_2 A1 A2 B1 C1 D1 VGND VNB VPB VPWR Y
.ends

* Black-box entry subcircuit for sky130_fd_sc_hd__a211o_2 abstract view
.subckt sky130_fd_sc_hd__a211o_2 A1 A2 B1 C1 VGND VNB VPB VPWR X
.ends

* Black-box entry subcircuit for sky130_fd_sc_hd__o221a_4 abstract view
.subckt sky130_fd_sc_hd__o221a_4 A1 A2 B1 B2 C1 VGND VNB VPB VPWR X
.ends

* Black-box entry subcircuit for sky130_fd_sc_hd__or2_4 abstract view
.subckt sky130_fd_sc_hd__or2_4 A B VGND VNB VPB VPWR X
.ends

* Black-box entry subcircuit for sky130_fd_sc_hd__a311oi_2 abstract view
.subckt sky130_fd_sc_hd__a311oi_2 A1 A2 A3 B1 C1 VGND VNB VPB VPWR Y
.ends

* Black-box entry subcircuit for sky130_fd_sc_hd__dlygate4sd1_1 abstract view
.subckt sky130_fd_sc_hd__dlygate4sd1_1 A VGND VNB VPB VPWR X
.ends

* Black-box entry subcircuit for sky130_fd_sc_hd__and2b_4 abstract view
.subckt sky130_fd_sc_hd__and2b_4 A_N B VGND VNB VPB VPWR X
.ends

* Black-box entry subcircuit for sky130_fd_sc_hd__a2bb2o_2 abstract view
.subckt sky130_fd_sc_hd__a2bb2o_2 A1_N A2_N B1 B2 VGND VNB VPB VPWR X
.ends

* Black-box entry subcircuit for sky130_fd_sc_hd__xor2_4 abstract view
.subckt sky130_fd_sc_hd__xor2_4 A B VGND VNB VPB VPWR X
.ends

.subckt addsub32 A[0] A[10] A[11] A[12] A[13] A[14] A[15] A[16] A[17] A[18] A[19]
+ A[1] A[20] A[21] A[22] A[23] A[24] A[25] A[26] A[27] A[28] A[29] A[2] A[30] A[31]
+ A[3] A[4] A[5] A[6] A[7] A[8] A[9] B[0] B[10] B[11] B[12] B[13] B[14] B[15] B[16]
+ B[17] B[18] B[19] B[1] B[20] B[21] B[22] B[23] B[24] B[25] B[26] B[27] B[28] B[29]
+ B[2] B[30] B[31] B[3] B[4] B[5] B[6] B[7] B[8] B[9] S[0] S[10] S[11] S[12] S[13]
+ S[14] S[15] S[16] S[17] S[18] S[19] S[1] S[20] S[21] S[22] S[23] S[24] S[25] S[26]
+ S[27] S[28] S[29] S[2] S[30] S[31] S[3] S[4] S[5] S[6] S[7] S[8] S[9] VGND VPWR
+ carryOut sub
XFILLER_22_144 VGND VGND VPWR VPWR sky130_fd_sc_hd__decap_3
XFILLER_22_133 VGND VGND VPWR VPWR sky130_fd_sc_hd__decap_3
XFILLER_22_100 VGND VGND VPWR VPWR sky130_fd_sc_hd__decap_3
XFILLER_13_122 VGND VGND VPWR VPWR sky130_fd_sc_hd__decap_3
X_501_ _530_/A _502_/B VGND VGND VPWR VPWR _503_/A sky130_fd_sc_hd__and2_4
X_432_ _392_/Y _420_/Y _383_/Y VGND VGND VPWR VPWR _432_/Y sky130_fd_sc_hd__o21bai_4
XTAP_TAPCELL_ROW_15_128 VGND VPWR sky130_fd_sc_hd__tapvpwrvgnd_1
XFILLER_26_85 VGND VGND VPWR VPWR sky130_fd_sc_hd__decap_3
XFILLER_26_52 VGND VGND VPWR VPWR sky130_fd_sc_hd__decap_3
XFILLER_13_188 VGND VGND VPWR VPWR sky130_fd_sc_hd__fill_2
X_363_ _366_/B _363_/B VGND VGND VPWR VPWR _367_/B sky130_fd_sc_hd__nand2b_4
XFILLER_9_137 VGND VGND VPWR VPWR sky130_fd_sc_hd__decap_3
Xfanout105 fanout107/X VGND VGND VPWR VPWR _660_/A sky130_fd_sc_hd__buf_8
Xfanout116 _671_/B VGND VGND VPWR VPWR _602_/A sky130_fd_sc_hd__buf_4
XFILLER_10_103 VGND VGND VPWR VPWR sky130_fd_sc_hd__fill_1
XFILLER_10_125 VGND VGND VPWR VPWR sky130_fd_sc_hd__decap_3
XFILLER_10_147 VGND VGND VPWR VPWR sky130_fd_sc_hd__decap_3
XFILLER_12_98 VGND VGND VPWR VPWR sky130_fd_sc_hd__decap_3
X_415_ _400_/A _401_/Y _407_/X _413_/Y VGND VGND VPWR VPWR _415_/Y sky130_fd_sc_hd__o211ai_4
XFILLER_5_184 VGND VGND VPWR VPWR sky130_fd_sc_hd__fill_2
XFILLER_23_75 VGND VGND VPWR VPWR sky130_fd_sc_hd__fill_2
XFILLER_0_24 VGND VGND VPWR VPWR sky130_fd_sc_hd__fill_1
XFILLER_9_88 VGND VGND VPWR VPWR sky130_fd_sc_hd__decap_3
XFILLER_9_66 VGND VGND VPWR VPWR sky130_fd_sc_hd__decap_3
X_680_ _705_/A _680_/B VGND VGND VPWR VPWR _680_/Y sky130_fd_sc_hd__nor2_2
XFILLER_18_75 VGND VGND VPWR VPWR sky130_fd_sc_hd__decap_3
XFILLER_34_85 VGND VGND VPWR VPWR sky130_fd_sc_hd__fill_1
XPHY_EDGE_ROW_28_Left_63 VGND VGND VPWR VPWR sky130_fd_sc_hd__decap_3
XPHY_EDGE_ROW_12_Left_47 VGND VGND VPWR VPWR sky130_fd_sc_hd__decap_3
XFILLER_29_139 VGND VGND VPWR VPWR sky130_fd_sc_hd__decap_3
X_732_ _735_/B _734_/B VGND VGND VPWR VPWR _732_/X sky130_fd_sc_hd__and2_2
X_594_ _594_/A _594_/B input22/X VGND VGND VPWR VPWR _607_/B sky130_fd_sc_hd__or3b_2
X_663_ _663_/A VGND VGND VPWR VPWR _663_/Y sky130_fd_sc_hd__inv_2
XFILLER_28_194 VGND VGND VPWR VPWR sky130_fd_sc_hd__fill_2
XFILLER_28_161 VGND VGND VPWR VPWR sky130_fd_sc_hd__decap_3
XFILLER_6_34 VGND VGND VPWR VPWR sky130_fd_sc_hd__decap_3
XFILLER_6_67 VGND VGND VPWR VPWR sky130_fd_sc_hd__fill_1
XFILLER_26_109 VGND VGND VPWR VPWR sky130_fd_sc_hd__decap_3
XFILLER_19_172 VGND VGND VPWR VPWR sky130_fd_sc_hd__decap_3
XFILLER_34_197 VGND VGND VPWR VPWR sky130_fd_sc_hd__decap_3
XFILLER_34_186 VGND VGND VPWR VPWR sky130_fd_sc_hd__decap_3
Xrebuffer129 _369_/A1 VGND VGND VPWR VPWR _355_/B sky130_fd_sc_hd__buf_2
Xrebuffer118 _727_/B VGND VGND VPWR VPWR _382_/B2 sky130_fd_sc_hd__buf_2
XFILLER_25_164 VGND VGND VPWR VPWR sky130_fd_sc_hd__decap_3
XFILLER_25_186 VGND VGND VPWR VPWR sky130_fd_sc_hd__decap_3
XFILLER_15_87 VGND VGND VPWR VPWR sky130_fd_sc_hd__decap_3
Xoutput75 _458_/X VGND VGND VPWR VPWR S[18] sky130_fd_sc_hd__buf_6
X_715_ _735_/B _714_/B _715_/B1 VGND VGND VPWR VPWR _715_/Y sky130_fd_sc_hd__o21ai_2
Xoutput97 _646_/X VGND VGND VPWR VPWR S[9] sky130_fd_sc_hd__buf_4
Xoutput86 _591_/X VGND VGND VPWR VPWR S[28] sky130_fd_sc_hd__clkbuf_2
X_577_ _602_/A _577_/B VGND VGND VPWR VPWR _579_/B sky130_fd_sc_hd__and2_2
X_646_ _717_/Y _646_/B VGND VGND VPWR VPWR _646_/X sky130_fd_sc_hd__xor2_2
XTAP_TAPCELL_ROW_18_137 VGND VPWR sky130_fd_sc_hd__tapvpwrvgnd_1
XFILLER_31_145 VGND VGND VPWR VPWR sky130_fd_sc_hd__fill_2
XFILLER_16_175 VGND VGND VPWR VPWR sky130_fd_sc_hd__fill_2
XFILLER_31_178 VGND VGND VPWR VPWR sky130_fd_sc_hd__decap_3
XFILLER_22_167 VGND VGND VPWR VPWR sky130_fd_sc_hd__fill_1
XFILLER_22_112 VGND VGND VPWR VPWR sky130_fd_sc_hd__decap_3
XTAP_TAPCELL_ROW_9_105 VGND VPWR sky130_fd_sc_hd__tapvpwrvgnd_1
XPHY_EDGE_ROW_15_Left_50 VGND VGND VPWR VPWR sky130_fd_sc_hd__decap_3
X_500_ _511_/B _497_/B _488_/X _498_/X VGND VGND VPWR VPWR _508_/A sky130_fd_sc_hd__o2bb2ai_2
XFILLER_13_101 VGND VGND VPWR VPWR sky130_fd_sc_hd__decap_3
XFILLER_13_167 VGND VGND VPWR VPWR sky130_fd_sc_hd__fill_1
X_431_ _431_/A _431_/B _727_/Y VGND VGND VPWR VPWR _433_/B sky130_fd_sc_hd__nand3_2
X_362_ _738_/X _358_/Y _354_/Y _360_/Y VGND VGND VPWR VPWR _636_/A sky130_fd_sc_hd__o22ai_2
XFILLER_9_116 VGND VGND VPWR VPWR sky130_fd_sc_hd__decap_3
XFILLER_26_97 VGND VGND VPWR VPWR sky130_fd_sc_hd__decap_3
XFILLER_26_64 VGND VGND VPWR VPWR sky130_fd_sc_hd__decap_3
XFILLER_9_149 VGND VGND VPWR VPWR sky130_fd_sc_hd__fill_2
XFILLER_3_68 VGND VGND VPWR VPWR sky130_fd_sc_hd__decap_3
XFILLER_3_57 VGND VGND VPWR VPWR sky130_fd_sc_hd__fill_2
XFILLER_3_24 VGND VGND VPWR VPWR sky130_fd_sc_hd__decap_3
X_629_ _628_/A _629_/A2 _629_/B1 _629_/C1 VGND VGND VPWR VPWR _630_/B sky130_fd_sc_hd__o211a_2
XFILLER_8_193 VGND VGND VPWR VPWR sky130_fd_sc_hd__decap_3
Xfanout106 fanout107/X VGND VGND VPWR VPWR _738_/A sky130_fd_sc_hd__clkbuf_2
Xfanout117 input65/X VGND VGND VPWR VPWR _671_/B sky130_fd_sc_hd__buf_2
XFILLER_10_137 VGND VGND VPWR VPWR sky130_fd_sc_hd__decap_3
XFILLER_12_55 VGND VGND VPWR VPWR sky130_fd_sc_hd__decap_3
XFILLER_12_66 VGND VGND VPWR VPWR sky130_fd_sc_hd__decap_3
XTAP_TAPCELL_ROW_20_143 VGND VPWR sky130_fd_sc_hd__tapvpwrvgnd_1
XPHY_EDGE_ROW_0_Left_35 VGND VGND VPWR VPWR sky130_fd_sc_hd__decap_3
XFILLER_33_207 VGND VGND VPWR VPWR sky130_fd_sc_hd__fill_1
X_414_ _400_/Y _631_/A1 _412_/Y _413_/A VGND VGND VPWR VPWR _414_/Y sky130_fd_sc_hd__a22oi_2
XPHY_EDGE_ROW_12_Right_12 VGND VGND VPWR VPWR sky130_fd_sc_hd__decap_3
XFILLER_15_207 VGND VGND VPWR VPWR sky130_fd_sc_hd__fill_1
XPHY_EDGE_ROW_21_Right_21 VGND VGND VPWR VPWR sky130_fd_sc_hd__decap_3
XPHY_EDGE_ROW_30_Right_30 VGND VGND VPWR VPWR sky130_fd_sc_hd__decap_3
XFILLER_2_133 VGND VGND VPWR VPWR sky130_fd_sc_hd__fill_1
XFILLER_9_78 VGND VGND VPWR VPWR sky130_fd_sc_hd__decap_3
XFILLER_20_88 VGND VGND VPWR VPWR sky130_fd_sc_hd__decap_3
XFILLER_20_77 VGND VGND VPWR VPWR sky130_fd_sc_hd__decap_3
X_662_ _738_/B VGND VGND VPWR VPWR _662_/Y sky130_fd_sc_hd__inv_2
X_731_ _375_/B1 _731_/B _731_/C VGND VGND VPWR VPWR _731_/Y sky130_fd_sc_hd__nand3b_4
XFILLER_29_86 VGND VGND VPWR VPWR sky130_fd_sc_hd__decap_3
X_593_ _671_/B _593_/B VGND VGND VPWR VPWR _594_/B sky130_fd_sc_hd__and2_2
XFILLER_6_46 VGND VGND VPWR VPWR sky130_fd_sc_hd__decap_3
XFILLER_19_162 VGND VGND VPWR VPWR sky130_fd_sc_hd__decap_3
XFILLER_19_140 VGND VGND VPWR VPWR sky130_fd_sc_hd__decap_3
Xrebuffer119 rebuffer167/X VGND VGND VPWR VPWR _438_/B sky130_fd_sc_hd__buf_6
XPHY_EDGE_ROW_6_Right_6 VGND VGND VPWR VPWR sky130_fd_sc_hd__decap_3
XFILLER_15_55 VGND VGND VPWR VPWR sky130_fd_sc_hd__fill_1
XFILLER_15_66 VGND VGND VPWR VPWR sky130_fd_sc_hd__decap_3
XFILLER_15_99 VGND VGND VPWR VPWR sky130_fd_sc_hd__decap_3
Xoutput98 _659_/X VGND VGND VPWR VPWR carryOut sky130_fd_sc_hd__buf_2
Xoutput87 _600_/Y VGND VGND VPWR VPWR S[29] sky130_fd_sc_hd__clkbuf_4
Xoutput76 _468_/Y VGND VGND VPWR VPWR S[19] sky130_fd_sc_hd__buf_6
X_645_ _718_/X _720_/Y _723_/X _643_/A VGND VGND VPWR VPWR _646_/B sky130_fd_sc_hd__o22a_2
X_714_ _735_/B _714_/B VGND VGND VPWR VPWR _714_/X sky130_fd_sc_hd__and2_2
XTAP_TAPCELL_ROW_18_138 VGND VPWR sky130_fd_sc_hd__tapvpwrvgnd_1
XFILLER_16_121 VGND VGND VPWR VPWR sky130_fd_sc_hd__fill_1
X_576_ _602_/A _577_/B VGND VGND VPWR VPWR _579_/A sky130_fd_sc_hd__nor2_2
XFILLER_31_113 VGND VGND VPWR VPWR sky130_fd_sc_hd__fill_1
XFILLER_22_124 VGND VGND VPWR VPWR sky130_fd_sc_hd__decap_3
XTAP_TAPCELL_ROW_32_185 VGND VPWR sky130_fd_sc_hd__tapvpwrvgnd_1
XTAP_TAPCELL_ROW_9_106 VGND VPWR sky130_fd_sc_hd__tapvpwrvgnd_1
XFILLER_13_113 VGND VGND VPWR VPWR sky130_fd_sc_hd__decap_3
X_430_ _431_/B _727_/Y _430_/C _430_/D VGND VGND VPWR VPWR _436_/C sky130_fd_sc_hd__nand4_4
X_361_ _358_/B1 _361_/B _361_/C VGND VGND VPWR VPWR _373_/A sky130_fd_sc_hd__nand3b_2
XFILLER_9_128 VGND VGND VPWR VPWR sky130_fd_sc_hd__decap_3
XFILLER_3_47 VGND VGND VPWR VPWR sky130_fd_sc_hd__fill_2
X_628_ _628_/A _628_/B VGND VGND VPWR VPWR _628_/Y sky130_fd_sc_hd__xnor2_2
X_559_ _558_/A _542_/X _558_/B VGND VGND VPWR VPWR _559_/Y sky130_fd_sc_hd__o21ai_2
XFILLER_8_150 VGND VGND VPWR VPWR sky130_fd_sc_hd__decap_3
Xfanout107 input65/X VGND VGND VPWR VPWR fanout107/X sky130_fd_sc_hd__buf_8
XTAP_TAPCELL_ROW_20_144 VGND VPWR sky130_fd_sc_hd__tapvpwrvgnd_1
X_413_ _413_/A _413_/B VGND VGND VPWR VPWR _413_/Y sky130_fd_sc_hd__nand2_2
XFILLER_23_66 VGND VGND VPWR VPWR sky130_fd_sc_hd__decap_3
XFILLER_23_55 VGND VGND VPWR VPWR sky130_fd_sc_hd__fill_1
XFILLER_3_3 VGND VGND VPWR VPWR sky130_fd_sc_hd__fill_1
XFILLER_23_99 VGND VGND VPWR VPWR sky130_fd_sc_hd__decap_3
XFILLER_0_15 VGND VGND VPWR VPWR sky130_fd_sc_hd__decap_3
XFILLER_9_57 VGND VGND VPWR VPWR sky130_fd_sc_hd__fill_2
XFILLER_34_43 VGND VGND VPWR VPWR sky130_fd_sc_hd__decap_3
XFILLER_18_88 VGND VGND VPWR VPWR sky130_fd_sc_hd__decap_3
XFILLER_18_66 VGND VGND VPWR VPWR sky130_fd_sc_hd__decap_3
X_592_ _671_/B _593_/B VGND VGND VPWR VPWR _594_/A sky130_fd_sc_hd__nor2_2
X_661_ _682_/B VGND VGND VPWR VPWR _683_/B sky130_fd_sc_hd__inv_2
X_730_ _738_/A _730_/B VGND VGND VPWR VPWR _730_/X sky130_fd_sc_hd__and2_2
XFILLER_29_98 VGND VGND VPWR VPWR sky130_fd_sc_hd__decap_3
XFILLER_28_152 VGND VGND VPWR VPWR sky130_fd_sc_hd__fill_1
XFILLER_28_141 VGND VGND VPWR VPWR sky130_fd_sc_hd__decap_3
XFILLER_6_58 VGND VGND VPWR VPWR sky130_fd_sc_hd__decap_3
XFILLER_34_122 VGND VGND VPWR VPWR sky130_fd_sc_hd__decap_3
XFILLER_34_111 VGND VGND VPWR VPWR sky130_fd_sc_hd__fill_1
XFILLER_19_152 VGND VGND VPWR VPWR sky130_fd_sc_hd__decap_3
XFILLER_34_177 VGND VGND VPWR VPWR sky130_fd_sc_hd__decap_3
XFILLER_25_177 VGND VGND VPWR VPWR sky130_fd_sc_hd__decap_3
XFILLER_25_155 VGND VGND VPWR VPWR sky130_fd_sc_hd__decap_3
XFILLER_25_122 VGND VGND VPWR VPWR sky130_fd_sc_hd__decap_3
XFILLER_25_111 VGND VGND VPWR VPWR sky130_fd_sc_hd__fill_1
XFILLER_15_78 VGND VGND VPWR VPWR sky130_fd_sc_hd__decap_3
Xoutput88 _630_/X VGND VGND VPWR VPWR S[2] sky130_fd_sc_hd__buf_6
Xoutput77 _628_/Y VGND VGND VPWR VPWR S[1] sky130_fd_sc_hd__buf_6
Xoutput66 _626_/X VGND VGND VPWR VPWR S[0] sky130_fd_sc_hd__clkdlybuf4s25_1
X_575_ _575_/A _575_/B VGND VGND VPWR VPWR _575_/Y sky130_fd_sc_hd__nand2_2
X_644_ _644_/A _644_/B VGND VGND VPWR VPWR _644_/X sky130_fd_sc_hd__or2_2
X_713_ _734_/A _714_/B VGND VGND VPWR VPWR _716_/C sky130_fd_sc_hd__nand2_2
XTAP_TAPCELL_ROW_18_139 VGND VPWR sky130_fd_sc_hd__tapvpwrvgnd_1
XFILLER_16_144 VGND VGND VPWR VPWR sky130_fd_sc_hd__decap_3
XFILLER_16_111 VGND VGND VPWR VPWR sky130_fd_sc_hd__decap_3
XFILLER_31_169 VGND VGND VPWR VPWR sky130_fd_sc_hd__decap_3
XFILLER_31_125 VGND VGND VPWR VPWR sky130_fd_sc_hd__fill_2
XFILLER_22_158 VGND VGND VPWR VPWR sky130_fd_sc_hd__decap_3
XFILLER_22_147 VGND VGND VPWR VPWR sky130_fd_sc_hd__fill_2
XFILLER_22_136 VGND VGND VPWR VPWR sky130_fd_sc_hd__decap_3
XFILLER_22_103 VGND VGND VPWR VPWR sky130_fd_sc_hd__decap_3
XTAP_TAPCELL_ROW_32_186 VGND VPWR sky130_fd_sc_hd__tapvpwrvgnd_1
XTAP_TAPCELL_ROW_9_107 VGND VPWR sky130_fd_sc_hd__tapvpwrvgnd_1
XFILLER_26_55 VGND VGND VPWR VPWR sky130_fd_sc_hd__decap_3
X_360_ _365_/A _662_/Y _358_/B1 VGND VGND VPWR VPWR _360_/Y sky130_fd_sc_hd__o21bai_2
XFILLER_26_88 VGND VGND VPWR VPWR sky130_fd_sc_hd__decap_3
X_558_ _558_/A _558_/B VGND VGND VPWR VPWR _558_/X sky130_fd_sc_hd__and2_2
X_627_ _409_/A _626_/A _627_/S VGND VGND VPWR VPWR _628_/B sky130_fd_sc_hd__mux2_1
X_489_ _487_/Y _486_/X _490_/B1 VGND VGND VPWR VPWR _489_/Y sky130_fd_sc_hd__o21bai_4
Xfanout108 _491_/A1 VGND VGND VPWR VPWR _486_/A sky130_fd_sc_hd__buf_6
XFILLER_10_128 VGND VGND VPWR VPWR sky130_fd_sc_hd__decap_3
XTAP_TAPCELL_ROW_20_145 VGND VPWR sky130_fd_sc_hd__tapvpwrvgnd_1
X_412_ _410_/Y _408_/X _406_/Y _404_/X VGND VGND VPWR VPWR _412_/Y sky130_fd_sc_hd__o22ai_2
XTAP_TAPCELL_ROW_11_112 VGND VPWR sky130_fd_sc_hd__tapvpwrvgnd_1
XFILLER_5_132 VGND VGND VPWR VPWR sky130_fd_sc_hd__decap_3
XFILLER_2_113 VGND VGND VPWR VPWR sky130_fd_sc_hd__fill_1
XFILLER_9_69 VGND VGND VPWR VPWR sky130_fd_sc_hd__decap_3
XTAP_TAPCELL_ROW_0_70 VGND VPWR sky130_fd_sc_hd__tapvpwrvgnd_1
XFILLER_18_78 VGND VGND VPWR VPWR sky130_fd_sc_hd__decap_3
X_591_ _598_/B _591_/B VGND VGND VPWR VPWR _591_/X sky130_fd_sc_hd__and2_4
X_660_ _660_/A VGND VGND VPWR VPWR _660_/Y sky130_fd_sc_hd__inv_6
XFILLER_29_77 VGND VGND VPWR VPWR sky130_fd_sc_hd__decap_3
XFILLER_28_197 VGND VGND VPWR VPWR sky130_fd_sc_hd__decap_3
XFILLER_28_164 VGND VGND VPWR VPWR sky130_fd_sc_hd__decap_3
XFILLER_19_131 VGND VGND VPWR VPWR sky130_fd_sc_hd__decap_3
XFILLER_34_189 VGND VGND VPWR VPWR sky130_fd_sc_hd__decap_3
XFILLER_19_175 VGND VGND VPWR VPWR sky130_fd_sc_hd__decap_3
XFILLER_15_57 VGND VGND VPWR VPWR sky130_fd_sc_hd__decap_3
XFILLER_25_167 VGND VGND VPWR VPWR sky130_fd_sc_hd__fill_1
XFILLER_0_200 VGND VGND VPWR VPWR sky130_fd_sc_hd__decap_3
X_712_ _714_/B _735_/B VGND VGND VPWR VPWR _716_/B sky130_fd_sc_hd__nand2b_2
Xoutput89 _614_/Y VGND VGND VPWR VPWR S[30] sky130_fd_sc_hd__buf_6
Xoutput78 _485_/X VGND VGND VPWR VPWR S[20] sky130_fd_sc_hd__buf_8
Xoutput67 _648_/X VGND VGND VPWR VPWR S[10] sky130_fd_sc_hd__clkbuf_2
X_574_ _574_/A _574_/B _583_/C _583_/D VGND VGND VPWR VPWR _575_/B sky130_fd_sc_hd__nand4_2
X_643_ _643_/A _643_/B _643_/C VGND VGND VPWR VPWR _644_/B sky130_fd_sc_hd__and3_2
XFILLER_11_3 VGND VGND VPWR VPWR sky130_fd_sc_hd__fill_1
XFILLER_22_115 VGND VGND VPWR VPWR sky130_fd_sc_hd__decap_3
XTAP_TAPCELL_ROW_32_187 VGND VPWR sky130_fd_sc_hd__tapvpwrvgnd_1
XFILLER_13_104 VGND VGND VPWR VPWR sky130_fd_sc_hd__decap_3
XFILLER_26_78 VGND VGND VPWR VPWR sky130_fd_sc_hd__decap_3
XFILLER_26_67 VGND VGND VPWR VPWR sky130_fd_sc_hd__fill_1
XTAP_TAPCELL_ROW_23_154 VGND VPWR sky130_fd_sc_hd__tapvpwrvgnd_1
XFILLER_9_119 VGND VGND VPWR VPWR sky130_fd_sc_hd__decap_3
XFILLER_21_181 VGND VGND VPWR VPWR sky130_fd_sc_hd__decap_3
XFILLER_3_27 VGND VGND VPWR VPWR sky130_fd_sc_hd__fill_1
X_557_ _557_/A _557_/B _558_/A _558_/B VGND VGND VPWR VPWR _583_/B sky130_fd_sc_hd__and4_4
X_626_ _626_/A _627_/S VGND VGND VPWR VPWR _626_/X sky130_fd_sc_hd__xor2_2
X_488_ _486_/X _487_/Y _490_/B1 VGND VGND VPWR VPWR _488_/X sky130_fd_sc_hd__o21ba_2
XFILLER_8_141 VGND VGND VPWR VPWR sky130_fd_sc_hd__decap_3
Xfanout109 input65/X VGND VGND VPWR VPWR _491_/A1 sky130_fd_sc_hd__dlymetal6s2s_1
XPHY_EDGE_ROW_19_Left_54 VGND VGND VPWR VPWR sky130_fd_sc_hd__decap_3
XTAP_TAPCELL_ROW_20_146 VGND VPWR sky130_fd_sc_hd__tapvpwrvgnd_1
XFILLER_12_69 VGND VGND VPWR VPWR sky130_fd_sc_hd__decap_3
X_411_ _439_/A _627_/S _410_/Y VGND VGND VPWR VPWR _413_/B sky130_fd_sc_hd__a21oi_2
XTAP_TAPCELL_ROW_11_113 VGND VPWR sky130_fd_sc_hd__tapvpwrvgnd_1
X_609_ _609_/A _609_/B VGND VGND VPWR VPWR _623_/A sky130_fd_sc_hd__nand2_2
XFILLER_4_92 VGND VGND VPWR VPWR sky130_fd_sc_hd__decap_3
XPHY_EDGE_ROW_4_Left_39 VGND VGND VPWR VPWR sky130_fd_sc_hd__decap_3
XFILLER_23_57 VGND VGND VPWR VPWR sky130_fd_sc_hd__decap_3
XFILLER_9_48 VGND VGND VPWR VPWR sky130_fd_sc_hd__decap_3
XTAP_TAPCELL_ROW_0_71 VGND VPWR sky130_fd_sc_hd__tapvpwrvgnd_1
X_590_ _580_/A _598_/A _609_/A VGND VGND VPWR VPWR _591_/B sky130_fd_sc_hd__a21o_2
XFILLER_29_89 VGND VGND VPWR VPWR sky130_fd_sc_hd__decap_3
XPHY_EDGE_ROW_7_Left_42 VGND VGND VPWR VPWR sky130_fd_sc_hd__decap_3
XFILLER_10_91 VGND VGND VPWR VPWR sky130_fd_sc_hd__decap_3
XFILLER_6_49 VGND VGND VPWR VPWR sky130_fd_sc_hd__decap_3
XFILLER_6_27 VGND VGND VPWR VPWR sky130_fd_sc_hd__fill_1
XFILLER_19_165 VGND VGND VPWR VPWR sky130_fd_sc_hd__decap_3
XFILLER_19_143 VGND VGND VPWR VPWR sky130_fd_sc_hd__decap_3
XFILLER_25_113 VGND VGND VPWR VPWR sky130_fd_sc_hd__decap_3
XFILLER_25_102 VGND VGND VPWR VPWR sky130_fd_sc_hd__decap_3
XFILLER_15_69 VGND VGND VPWR VPWR sky130_fd_sc_hd__decap_3
XPHY_EDGE_ROW_33_Left_68 VGND VGND VPWR VPWR sky130_fd_sc_hd__decap_3
XFILLER_31_57 VGND VGND VPWR VPWR sky130_fd_sc_hd__decap_3
X_642_ _643_/C _643_/B _643_/A VGND VGND VPWR VPWR _644_/A sky130_fd_sc_hd__a21oi_2
X_711_ _711_/A _711_/B _711_/C _711_/D VGND VGND VPWR VPWR _727_/B sky130_fd_sc_hd__nand4_4
Xoutput79 _495_/Y VGND VGND VPWR VPWR S[21] sky130_fd_sc_hd__buf_8
Xoutput68 _650_/X VGND VGND VPWR VPWR S[11] sky130_fd_sc_hd__buf_4
X_573_ _574_/B _574_/A _570_/Y _571_/X VGND VGND VPWR VPWR _575_/A sky130_fd_sc_hd__o2bb2ai_2
XPHY_EDGE_ROW_19_Right_19 VGND VGND VPWR VPWR sky130_fd_sc_hd__decap_3
XPHY_EDGE_ROW_28_Right_28 VGND VGND VPWR VPWR sky130_fd_sc_hd__decap_3
XTAP_TAPCELL_ROW_32_188 VGND VPWR sky130_fd_sc_hd__tapvpwrvgnd_1
XFILLER_22_127 VGND VGND VPWR VPWR sky130_fd_sc_hd__decap_3
XFILLER_13_116 VGND VGND VPWR VPWR sky130_fd_sc_hd__decap_3
XFILLER_26_46 VGND VGND VPWR VPWR sky130_fd_sc_hd__decap_3
XTAP_TAPCELL_ROW_23_155 VGND VPWR sky130_fd_sc_hd__tapvpwrvgnd_1
X_625_ _615_/Y _622_/X _623_/Y _624_/Y VGND VGND VPWR VPWR _625_/Y sky130_fd_sc_hd__a22oi_4
X_556_ _562_/A VGND VGND VPWR VPWR _583_/A sky130_fd_sc_hd__inv_2
X_487_ _530_/A _487_/B VGND VGND VPWR VPWR _487_/Y sky130_fd_sc_hd__nor2_2
XTAP_TAPCELL_ROW_14_122 VGND VPWR sky130_fd_sc_hd__tapvpwrvgnd_1
XFILLER_8_197 VGND VGND VPWR VPWR sky130_fd_sc_hd__decap_3
XFILLER_8_153 VGND VGND VPWR VPWR sky130_fd_sc_hd__decap_3
XFILLER_12_37 VGND VGND VPWR VPWR sky130_fd_sc_hd__fill_2
X_410_ _404_/A _627_/S _626_/A VGND VGND VPWR VPWR _410_/Y sky130_fd_sc_hd__o21ai_4
XTAP_TAPCELL_ROW_11_114 VGND VPWR sky130_fd_sc_hd__tapvpwrvgnd_1
X_608_ _588_/B _588_/A _609_/B VGND VGND VPWR VPWR _615_/B sky130_fd_sc_hd__a21boi_2
XPHY_EDGE_ROW_20_Left_55 VGND VGND VPWR VPWR sky130_fd_sc_hd__decap_3
X_539_ _537_/Y _539_/B VGND VGND VPWR VPWR _539_/X sky130_fd_sc_hd__and2b_2
XFILLER_4_71 VGND VGND VPWR VPWR sky130_fd_sc_hd__fill_1
XFILLER_23_69 VGND VGND VPWR VPWR sky130_fd_sc_hd__decap_3
XFILLER_0_18 VGND VGND VPWR VPWR sky130_fd_sc_hd__decap_3
XFILLER_0_29 VGND VGND VPWR VPWR sky130_fd_sc_hd__fill_1
XTAP_TAPCELL_ROW_0_72 VGND VPWR sky130_fd_sc_hd__tapvpwrvgnd_1
XFILLER_18_69 VGND VGND VPWR VPWR sky130_fd_sc_hd__decap_3
XFILLER_34_57 VGND VGND VPWR VPWR sky130_fd_sc_hd__decap_3
XFILLER_34_46 VGND VGND VPWR VPWR sky130_fd_sc_hd__fill_2
XFILLER_1_3 VGND VGND VPWR VPWR sky130_fd_sc_hd__decap_3
XFILLER_34_3 VGND VGND VPWR VPWR sky130_fd_sc_hd__decap_3
XFILLER_29_57 VGND VGND VPWR VPWR sky130_fd_sc_hd__decap_3
XFILLER_29_46 VGND VGND VPWR VPWR sky130_fd_sc_hd__fill_1
XFILLER_34_103 VGND VGND VPWR VPWR sky130_fd_sc_hd__decap_3
XFILLER_19_90 VGND VGND VPWR VPWR sky130_fd_sc_hd__decap_3
XFILLER_34_125 VGND VGND VPWR VPWR sky130_fd_sc_hd__decap_3
XFILLER_25_158 VGND VGND VPWR VPWR sky130_fd_sc_hd__decap_3
XFILLER_25_136 VGND VGND VPWR VPWR sky130_fd_sc_hd__decap_3
XFILLER_25_125 VGND VGND VPWR VPWR sky130_fd_sc_hd__fill_1
XFILLER_33_180 VGND VGND VPWR VPWR sky130_fd_sc_hd__decap_3
Xoutput69 _652_/X VGND VGND VPWR VPWR S[12] sky130_fd_sc_hd__dlymetal6s4s_1
X_572_ _569_/A _569_/B input20/X VGND VGND VPWR VPWR _583_/D sky130_fd_sc_hd__o21bai_2
X_641_ _731_/Y _641_/A2 _634_/B _431_/B VGND VGND VPWR VPWR _643_/A sky130_fd_sc_hd__a22oi_4
X_710_ _710_/A1 _708_/Y _710_/B1 VGND VGND VPWR VPWR _710_/Y sky130_fd_sc_hd__o21ai_2
XFILLER_16_114 VGND VGND VPWR VPWR sky130_fd_sc_hd__fill_2
XTAP_TAPCELL_ROW_26_164 VGND VPWR sky130_fd_sc_hd__tapvpwrvgnd_1
XFILLER_16_147 VGND VGND VPWR VPWR sky130_fd_sc_hd__decap_3
XFILLER_21_91 VGND VGND VPWR VPWR sky130_fd_sc_hd__decap_3
XFILLER_22_106 VGND VGND VPWR VPWR sky130_fd_sc_hd__decap_3
XFILLER_30_172 VGND VGND VPWR VPWR sky130_fd_sc_hd__decap_3
XFILLER_22_139 VGND VGND VPWR VPWR sky130_fd_sc_hd__fill_1
XFILLER_7_71 VGND VGND VPWR VPWR sky130_fd_sc_hd__decap_3
XFILLER_26_58 VGND VGND VPWR VPWR sky130_fd_sc_hd__decap_3
XTAP_TAPCELL_ROW_23_156 VGND VPWR sky130_fd_sc_hd__tapvpwrvgnd_1
XFILLER_21_161 VGND VGND VPWR VPWR sky130_fd_sc_hd__decap_3
X_555_ _555_/A _566_/A VGND VGND VPWR VPWR _562_/A sky130_fd_sc_hd__nand2_2
X_624_ _624_/A _624_/B VGND VGND VPWR VPWR _624_/Y sky130_fd_sc_hd__nor2_2
X_486_ _486_/A _487_/B VGND VGND VPWR VPWR _486_/X sky130_fd_sc_hd__and2_4
XTAP_TAPCELL_ROW_14_123 VGND VPWR sky130_fd_sc_hd__tapvpwrvgnd_1
XFILLER_8_121 VGND VGND VPWR VPWR sky130_fd_sc_hd__decap_3
XFILLER_16_91 VGND VGND VPWR VPWR sky130_fd_sc_hd__decap_3
XFILLER_12_49 VGND VGND VPWR VPWR sky130_fd_sc_hd__decap_3
XFILLER_5_135 VGND VGND VPWR VPWR sky130_fd_sc_hd__decap_3
XFILLER_5_113 VGND VGND VPWR VPWR sky130_fd_sc_hd__fill_1
X_538_ _558_/A _557_/B _564_/A VGND VGND VPWR VPWR _539_/B sky130_fd_sc_hd__a21o_2
X_607_ _607_/A _607_/B _607_/C VGND VGND VPWR VPWR _609_/B sky130_fd_sc_hd__and3_2
X_469_ _486_/A _471_/B VGND VGND VPWR VPWR _469_/Y sky130_fd_sc_hd__nor2_2
XFILLER_23_26 VGND VGND VPWR VPWR sky130_fd_sc_hd__decap_3
XTAP_TAPCELL_ROW_0_73 VGND VPWR sky130_fd_sc_hd__tapvpwrvgnd_1
XFILLER_1_193 VGND VGND VPWR VPWR sky130_fd_sc_hd__decap_3
XFILLER_24_91 VGND VGND VPWR VPWR sky130_fd_sc_hd__decap_3
XFILLER_28_178 VGND VGND VPWR VPWR sky130_fd_sc_hd__decap_3
XFILLER_28_167 VGND VGND VPWR VPWR sky130_fd_sc_hd__decap_3
XFILLER_19_178 VGND VGND VPWR VPWR sky130_fd_sc_hd__decap_3
XFILLER_19_134 VGND VGND VPWR VPWR sky130_fd_sc_hd__decap_3
XTAP_TAPCELL_ROW_6_94 VGND VPWR sky130_fd_sc_hd__tapvpwrvgnd_1
XFILLER_15_27 VGND VGND VPWR VPWR sky130_fd_sc_hd__fill_2
XFILLER_15_49 VGND VGND VPWR VPWR sky130_fd_sc_hd__decap_3
XFILLER_33_192 VGND VGND VPWR VPWR sky130_fd_sc_hd__decap_3
XFILLER_0_203 VGND VGND VPWR VPWR sky130_fd_sc_hd__decap_3
XPHY_EDGE_ROW_1_Right_1 VGND VGND VPWR VPWR sky130_fd_sc_hd__decap_3
X_571_ _569_/A _569_/B input20/X VGND VGND VPWR VPWR _571_/X sky130_fd_sc_hd__o21ba_2
X_640_ _640_/A _640_/B VGND VGND VPWR VPWR _640_/X sky130_fd_sc_hd__xor2_2
XTAP_TAPCELL_ROW_26_165 VGND VPWR sky130_fd_sc_hd__tapvpwrvgnd_1
XFILLER_24_170 VGND VGND VPWR VPWR sky130_fd_sc_hd__decap_3
XFILLER_21_70 VGND VGND VPWR VPWR sky130_fd_sc_hd__decap_3
XFILLER_22_118 VGND VGND VPWR VPWR sky130_fd_sc_hd__decap_3
XFILLER_13_107 VGND VGND VPWR VPWR sky130_fd_sc_hd__decap_3
XFILLER_21_140 VGND VGND VPWR VPWR sky130_fd_sc_hd__decap_3
X_554_ _553_/B _553_/C _664_/Y VGND VGND VPWR VPWR _566_/A sky130_fd_sc_hd__o21ai_2
X_623_ _623_/A _623_/B VGND VGND VPWR VPWR _623_/Y sky130_fd_sc_hd__nand2_2
X_485_ _485_/A _485_/B VGND VGND VPWR VPWR _485_/X sky130_fd_sc_hd__and2_4
XFILLER_12_151 VGND VGND VPWR VPWR sky130_fd_sc_hd__decap_3
XTAP_TAPCELL_ROW_14_124 VGND VPWR sky130_fd_sc_hd__tapvpwrvgnd_1
XFILLER_8_144 VGND VGND VPWR VPWR sky130_fd_sc_hd__decap_3
XFILLER_16_81 VGND VGND VPWR VPWR sky130_fd_sc_hd__decap_3
XTAP_TAPCELL_ROW_3_84 VGND VPWR sky130_fd_sc_hd__tapvpwrvgnd_1
X_537_ _537_/A1 _529_/A _536_/Y VGND VGND VPWR VPWR _537_/Y sky130_fd_sc_hd__a21oi_2
X_606_ _606_/A _624_/A VGND VGND VPWR VPWR _615_/A sky130_fd_sc_hd__nor2_2
X_468_ _468_/A _468_/B VGND VGND VPWR VPWR _468_/Y sky130_fd_sc_hd__xnor2_2
X_399_ _399_/A _399_/B VGND VGND VPWR VPWR _400_/B sky130_fd_sc_hd__nor2_2
XFILLER_4_95 VGND VGND VPWR VPWR sky130_fd_sc_hd__fill_2
XFILLER_23_49 VGND VGND VPWR VPWR sky130_fd_sc_hd__decap_3
XFILLER_13_60 VGND VGND VPWR VPWR sky130_fd_sc_hd__decap_3
XTAP_TAPCELL_ROW_0_74 VGND VPWR sky130_fd_sc_hd__tapvpwrvgnd_1
XFILLER_29_37 VGND VGND VPWR VPWR sky130_fd_sc_hd__fill_2
XFILLER_28_102 VGND VGND VPWR VPWR sky130_fd_sc_hd__fill_2
XFILLER_10_94 VGND VGND VPWR VPWR sky130_fd_sc_hd__decap_3
XFILLER_19_81 VGND VGND VPWR VPWR sky130_fd_sc_hd__decap_3
XFILLER_19_146 VGND VGND VPWR VPWR sky130_fd_sc_hd__decap_3
XTAP_TAPCELL_ROW_6_95 VGND VPWR sky130_fd_sc_hd__tapvpwrvgnd_1
XFILLER_25_105 VGND VGND VPWR VPWR sky130_fd_sc_hd__decap_3
XFILLER_25_116 VGND VGND VPWR VPWR sky130_fd_sc_hd__decap_3
XFILLER_31_38 VGND VGND VPWR VPWR sky130_fd_sc_hd__fill_1
X_570_ _583_/C VGND VGND VPWR VPWR _570_/Y sky130_fd_sc_hd__inv_2
XFILLER_16_105 VGND VGND VPWR VPWR sky130_fd_sc_hd__decap_3
XTAP_TAPCELL_ROW_26_166 VGND VPWR sky130_fd_sc_hd__tapvpwrvgnd_1
XFILLER_31_119 VGND VGND VPWR VPWR sky130_fd_sc_hd__decap_3
XFILLER_24_193 VGND VGND VPWR VPWR sky130_fd_sc_hd__decap_3
XFILLER_21_82 VGND VGND VPWR VPWR sky130_fd_sc_hd__decap_3
X_699_ _719_/A _699_/B VGND VGND VPWR VPWR _699_/Y sky130_fd_sc_hd__nor2_2
XTAP_TAPCELL_ROW_17_133 VGND VPWR sky130_fd_sc_hd__tapvpwrvgnd_1
XFILLER_7_95 VGND VGND VPWR VPWR sky130_fd_sc_hd__decap_3
XFILLER_7_51 VGND VGND VPWR VPWR sky130_fd_sc_hd__decap_3
XFILLER_30_163 VGND VGND VPWR VPWR sky130_fd_sc_hd__decap_3
XPHY_EDGE_ROW_15_Right_15 VGND VGND VPWR VPWR sky130_fd_sc_hd__decap_3
XPHY_EDGE_ROW_24_Right_24 VGND VGND VPWR VPWR sky130_fd_sc_hd__decap_3
XFILLER_26_49 VGND VGND VPWR VPWR sky130_fd_sc_hd__decap_3
XFILLER_26_27 VGND VGND VPWR VPWR sky130_fd_sc_hd__fill_1
XFILLER_13_119 VGND VGND VPWR VPWR sky130_fd_sc_hd__decap_3
XFILLER_21_152 VGND VGND VPWR VPWR sky130_fd_sc_hd__decap_3
XTAP_TAPCELL_ROW_8_101 VGND VPWR sky130_fd_sc_hd__tapvpwrvgnd_1
XPHY_EDGE_ROW_33_Right_33 VGND VGND VPWR VPWR sky130_fd_sc_hd__decap_3
X_622_ _620_/A _620_/B _624_/A _611_/A _604_/A VGND VGND VPWR VPWR _622_/X sky130_fd_sc_hd__o221a_2
X_553_ _664_/Y _553_/B _553_/C VGND VGND VPWR VPWR _555_/A sky130_fd_sc_hd__or3_4
X_484_ _474_/A _474_/B _511_/B VGND VGND VPWR VPWR _485_/B sky130_fd_sc_hd__a21o_2
XTAP_TAPCELL_ROW_14_125 VGND VPWR sky130_fd_sc_hd__tapvpwrvgnd_1
XFILLER_16_60 VGND VGND VPWR VPWR sky130_fd_sc_hd__decap_3
XFILLER_12_141 VGND VGND VPWR VPWR sky130_fd_sc_hd__decap_3
XTAP_TAPCELL_ROW_3_85 VGND VPWR sky130_fd_sc_hd__tapvpwrvgnd_1
XFILLER_8_156 VGND VGND VPWR VPWR sky130_fd_sc_hd__decap_3
XFILLER_5_159 VGND VGND VPWR VPWR sky130_fd_sc_hd__decap_3
X_605_ _603_/A _603_/B input24/X VGND VGND VPWR VPWR _624_/A sky130_fd_sc_hd__o21ba_2
X_536_ _558_/A _557_/B VGND VGND VPWR VPWR _536_/Y sky130_fd_sc_hd__nand2_2
X_467_ _458_/A _467_/A2 _454_/X _466_/X VGND VGND VPWR VPWR _468_/B sky130_fd_sc_hd__o31ai_4
X_398_ _399_/A _399_/B VGND VGND VPWR VPWR _400_/A sky130_fd_sc_hd__and2_4
XFILLER_4_170 VGND VGND VPWR VPWR sky130_fd_sc_hd__fill_2
XFILLER_13_50 VGND VGND VPWR VPWR sky130_fd_sc_hd__decap_3
XFILLER_13_72 VGND VGND VPWR VPWR sky130_fd_sc_hd__fill_2
XPHY_EDGE_ROW_24_Left_59 VGND VGND VPWR VPWR sky130_fd_sc_hd__decap_3
XTAP_TAPCELL_ROW_0_75 VGND VPWR sky130_fd_sc_hd__tapvpwrvgnd_1
XFILLER_29_8 VGND VGND VPWR VPWR sky130_fd_sc_hd__fill_1
X_519_ _519_/A _519_/B VGND VGND VPWR VPWR _523_/D sky130_fd_sc_hd__or2_2
XFILLER_11_206 VGND VGND VPWR VPWR sky130_fd_sc_hd__fill_2
XFILLER_1_6 VGND VGND VPWR VPWR sky130_fd_sc_hd__decap_3
XFILLER_24_82 VGND VGND VPWR VPWR sky130_fd_sc_hd__fill_2
XFILLER_34_6 VGND VGND VPWR VPWR sky130_fd_sc_hd__decap_3
XFILLER_1_53 VGND VGND VPWR VPWR sky130_fd_sc_hd__decap_3
XFILLER_1_75 VGND VGND VPWR VPWR sky130_fd_sc_hd__fill_1
XFILLER_28_158 VGND VGND VPWR VPWR sky130_fd_sc_hd__decap_3
XFILLER_10_73 VGND VGND VPWR VPWR sky130_fd_sc_hd__decap_3
XTAP_TAPCELL_ROW_29_175 VGND VPWR sky130_fd_sc_hd__tapvpwrvgnd_1
XFILLER_34_128 VGND VGND VPWR VPWR sky130_fd_sc_hd__decap_3
XFILLER_34_106 VGND VGND VPWR VPWR sky130_fd_sc_hd__fill_1
XFILLER_19_93 VGND VGND VPWR VPWR sky130_fd_sc_hd__decap_3
XFILLER_19_169 VGND VGND VPWR VPWR sky130_fd_sc_hd__decap_3
XTAP_TAPCELL_ROW_6_96 VGND VPWR sky130_fd_sc_hd__tapvpwrvgnd_1
XPHY_EDGE_ROW_27_Left_62 VGND VGND VPWR VPWR sky130_fd_sc_hd__decap_3
XPHY_EDGE_ROW_11_Left_46 VGND VGND VPWR VPWR sky130_fd_sc_hd__decap_3
XFILLER_25_139 VGND VGND VPWR VPWR sky130_fd_sc_hd__decap_3
XFILLER_33_183 VGND VGND VPWR VPWR sky130_fd_sc_hd__decap_3
XTAP_TAPCELL_ROW_26_167 VGND VPWR sky130_fd_sc_hd__tapvpwrvgnd_1
XFILLER_24_161 VGND VGND VPWR VPWR sky130_fd_sc_hd__decap_3
XFILLER_21_94 VGND VGND VPWR VPWR sky130_fd_sc_hd__decap_3
XFILLER_15_183 VGND VGND VPWR VPWR sky130_fd_sc_hd__fill_1
X_698_ _719_/A _699_/B VGND VGND VPWR VPWR _698_/X sky130_fd_sc_hd__and2_4
XTAP_TAPCELL_ROW_17_134 VGND VPWR sky130_fd_sc_hd__tapvpwrvgnd_1
XFILLER_22_109 VGND VGND VPWR VPWR sky130_fd_sc_hd__decap_3
XFILLER_7_74 VGND VGND VPWR VPWR sky130_fd_sc_hd__decap_3
XFILLER_30_197 VGND VGND VPWR VPWR sky130_fd_sc_hd__decap_3
XFILLER_21_164 VGND VGND VPWR VPWR sky130_fd_sc_hd__decap_3
XFILLER_21_131 VGND VGND VPWR VPWR sky130_fd_sc_hd__decap_3
XTAP_TAPCELL_ROW_8_102 VGND VPWR sky130_fd_sc_hd__tapvpwrvgnd_1
X_621_ _596_/X _598_/A _607_/B _604_/A VGND VGND VPWR VPWR _623_/B sky130_fd_sc_hd__o211a_2
XFILLER_12_131 VGND VGND VPWR VPWR sky130_fd_sc_hd__fill_2
X_552_ _602_/A _552_/B VGND VGND VPWR VPWR _553_/C sky130_fd_sc_hd__and2_2
X_483_ _510_/A _511_/B VGND VGND VPWR VPWR _485_/A sky130_fd_sc_hd__nand2_4
XFILLER_16_94 VGND VGND VPWR VPWR sky130_fd_sc_hd__decap_3
XFILLER_16_72 VGND VGND VPWR VPWR sky130_fd_sc_hd__decap_3
XFILLER_12_197 VGND VGND VPWR VPWR sky130_fd_sc_hd__decap_3
XTAP_TAPCELL_ROW_3_86 VGND VPWR sky130_fd_sc_hd__tapvpwrvgnd_1
X_535_ _530_/Y _531_/X _534_/C VGND VGND VPWR VPWR _557_/B sky130_fd_sc_hd__o21bai_4
X_604_ _604_/A VGND VGND VPWR VPWR _606_/A sky130_fd_sc_hd__inv_2
X_466_ _480_/A _456_/X _479_/B VGND VGND VPWR VPWR _466_/X sky130_fd_sc_hd__o21a_2
X_397_ _738_/A _395_/B _420_/A1 VGND VGND VPWR VPWR _397_/Y sky130_fd_sc_hd__o21ai_2
XFILLER_4_182 VGND VGND VPWR VPWR sky130_fd_sc_hd__decap_3
XFILLER_23_29 VGND VGND VPWR VPWR sky130_fd_sc_hd__decap_3
XFILLER_13_84 VGND VGND VPWR VPWR sky130_fd_sc_hd__decap_3
XFILLER_13_95 VGND VGND VPWR VPWR sky130_fd_sc_hd__decap_3
XTAP_TAPCELL_ROW_0_76 VGND VPWR sky130_fd_sc_hd__tapvpwrvgnd_1
XFILLER_1_196 VGND VGND VPWR VPWR sky130_fd_sc_hd__decap_3
XFILLER_1_185 VGND VGND VPWR VPWR sky130_fd_sc_hd__fill_1
X_518_ _519_/A _519_/B VGND VGND VPWR VPWR _518_/Y sky130_fd_sc_hd__nor2_2
X_449_ _461_/A _449_/B VGND VGND VPWR VPWR _450_/B sky130_fd_sc_hd__nand2_2
XFILLER_24_94 VGND VGND VPWR VPWR sky130_fd_sc_hd__decap_3
XFILLER_1_21 VGND VGND VPWR VPWR sky130_fd_sc_hd__decap_3
XFILLER_10_85 VGND VGND VPWR VPWR sky130_fd_sc_hd__decap_3
XFILLER_19_72 VGND VGND VPWR VPWR sky130_fd_sc_hd__decap_3
XFILLER_19_137 VGND VGND VPWR VPWR sky130_fd_sc_hd__decap_3
XTAP_TAPCELL_ROW_6_97 VGND VPWR sky130_fd_sc_hd__tapvpwrvgnd_1
XTAP_TAPCELL_ROW_29_176 VGND VPWR sky130_fd_sc_hd__tapvpwrvgnd_1
XFILLER_25_3 VGND VGND VPWR VPWR sky130_fd_sc_hd__fill_2
XFILLER_33_195 VGND VGND VPWR VPWR sky130_fd_sc_hd__decap_3
XFILLER_0_206 VGND VGND VPWR VPWR sky130_fd_sc_hd__fill_2
XFILLER_24_173 VGND VGND VPWR VPWR sky130_fd_sc_hd__decap_3
XFILLER_21_73 VGND VGND VPWR VPWR sky130_fd_sc_hd__decap_3
X_697_ _697_/A _697_/B _697_/C _697_/D VGND VGND VPWR VPWR _697_/Y sky130_fd_sc_hd__nand4_2
XTAP_TAPCELL_ROW_17_135 VGND VPWR sky130_fd_sc_hd__tapvpwrvgnd_1
XFILLER_15_140 VGND VGND VPWR VPWR sky130_fd_sc_hd__decap_3
XPHY_EDGE_ROW_5_Right_5 VGND VGND VPWR VPWR sky130_fd_sc_hd__decap_3
XFILLER_26_29 VGND VGND VPWR VPWR sky130_fd_sc_hd__fill_2
XTAP_TAPCELL_ROW_31_182 VGND VPWR sky130_fd_sc_hd__tapvpwrvgnd_1
XFILLER_21_143 VGND VGND VPWR VPWR sky130_fd_sc_hd__decap_3
XTAP_TAPCELL_ROW_8_103 VGND VPWR sky130_fd_sc_hd__tapvpwrvgnd_1
X_551_ _602_/A _552_/B VGND VGND VPWR VPWR _553_/B sky130_fd_sc_hd__nor2_2
X_620_ _620_/A _620_/B VGND VGND VPWR VPWR _624_/B sky130_fd_sc_hd__or2_2
XFILLER_12_110 VGND VGND VPWR VPWR sky130_fd_sc_hd__decap_3
X_482_ _480_/B _478_/X _437_/Y _482_/B2 VGND VGND VPWR VPWR _511_/B sky130_fd_sc_hd__o22ai_4
XFILLER_16_51 VGND VGND VPWR VPWR sky130_fd_sc_hd__decap_3
XFILLER_8_147 VGND VGND VPWR VPWR sky130_fd_sc_hd__decap_3
X_534_ _530_/Y _534_/B _534_/C VGND VGND VPWR VPWR _558_/A sky130_fd_sc_hd__nand3b_4
X_603_ _603_/A _603_/B input24/X VGND VGND VPWR VPWR _604_/A sky130_fd_sc_hd__or3b_2
X_465_ _476_/C _476_/A VGND VGND VPWR VPWR _468_/A sky130_fd_sc_hd__nand2_2
X_396_ _416_/B _416_/C VGND VGND VPWR VPWR _396_/Y sky130_fd_sc_hd__nand2_2
XFILLER_4_65 VGND VGND VPWR VPWR sky130_fd_sc_hd__decap_3
XFILLER_4_150 VGND VGND VPWR VPWR sky130_fd_sc_hd__fill_2
XFILLER_13_63 VGND VGND VPWR VPWR sky130_fd_sc_hd__decap_3
XFILLER_1_153 VGND VGND VPWR VPWR sky130_fd_sc_hd__fill_1
X_517_ _519_/A _519_/B VGND VGND VPWR VPWR _523_/C sky130_fd_sc_hd__nand2_2
X_448_ _486_/A _449_/B VGND VGND VPWR VPWR _448_/X sky130_fd_sc_hd__and2_2
X_379_ _379_/A _731_/Y _727_/Y VGND VGND VPWR VPWR _436_/A sky130_fd_sc_hd__nand3_4
XFILLER_34_29 VGND VGND VPWR VPWR sky130_fd_sc_hd__fill_2
XFILLER_1_44 VGND VGND VPWR VPWR sky130_fd_sc_hd__fill_1
XFILLER_28_138 VGND VGND VPWR VPWR sky130_fd_sc_hd__fill_2
XFILLER_28_149 VGND VGND VPWR VPWR sky130_fd_sc_hd__decap_3
XFILLER_10_97 VGND VGND VPWR VPWR sky130_fd_sc_hd__decap_3
XTAP_TAPCELL_ROW_29_177 VGND VPWR sky130_fd_sc_hd__tapvpwrvgnd_1
XFILLER_19_84 VGND VGND VPWR VPWR sky130_fd_sc_hd__decap_3
XFILLER_19_149 VGND VGND VPWR VPWR sky130_fd_sc_hd__decap_3
XFILLER_18_3 VGND VGND VPWR VPWR sky130_fd_sc_hd__fill_2
XFILLER_25_119 VGND VGND VPWR VPWR sky130_fd_sc_hd__decap_3
XFILLER_25_108 VGND VGND VPWR VPWR sky130_fd_sc_hd__decap_3
XFILLER_18_171 VGND VGND VPWR VPWR sky130_fd_sc_hd__fill_1
XFILLER_16_108 VGND VGND VPWR VPWR sky130_fd_sc_hd__decap_3
XFILLER_24_141 VGND VGND VPWR VPWR sky130_fd_sc_hd__decap_3
XFILLER_21_85 VGND VGND VPWR VPWR sky130_fd_sc_hd__decap_3
XFILLER_21_52 VGND VGND VPWR VPWR sky130_fd_sc_hd__decap_3
XFILLER_15_152 VGND VGND VPWR VPWR sky130_fd_sc_hd__decap_3
X_696_ _697_/A _697_/B VGND VGND VPWR VPWR _696_/Y sky130_fd_sc_hd__nand2_2
XFILLER_7_54 VGND VGND VPWR VPWR sky130_fd_sc_hd__fill_2
XFILLER_30_166 VGND VGND VPWR VPWR sky130_fd_sc_hd__decap_3
XFILLER_7_98 VGND VGND VPWR VPWR sky130_fd_sc_hd__fill_1
XFILLER_7_65 VGND VGND VPWR VPWR sky130_fd_sc_hd__decap_3
XFILLER_21_122 VGND VGND VPWR VPWR sky130_fd_sc_hd__decap_3
XFILLER_21_100 VGND VGND VPWR VPWR sky130_fd_sc_hd__decap_3
XTAP_TAPCELL_ROW_31_183 VGND VPWR sky130_fd_sc_hd__tapvpwrvgnd_1
XFILLER_21_155 VGND VGND VPWR VPWR sky130_fd_sc_hd__decap_3
XTAP_TAPCELL_ROW_8_104 VGND VPWR sky130_fd_sc_hd__tapvpwrvgnd_1
X_550_ _550_/A _550_/B VGND VGND VPWR VPWR _550_/Y sky130_fd_sc_hd__nor2_4
X_481_ _479_/Y _480_/Y _476_/C VGND VGND VPWR VPWR _481_/Y sky130_fd_sc_hd__a21boi_2
XFILLER_12_122 VGND VGND VPWR VPWR sky130_fd_sc_hd__decap_3
XTAP_TAPCELL_ROW_22_150 VGND VPWR sky130_fd_sc_hd__tapvpwrvgnd_1
XPHY_EDGE_ROW_11_Right_11 VGND VGND VPWR VPWR sky130_fd_sc_hd__decap_3
XFILLER_8_159 VGND VGND VPWR VPWR sky130_fd_sc_hd__fill_2
XFILLER_16_85 VGND VGND VPWR VPWR sky130_fd_sc_hd__decap_3
XFILLER_16_63 VGND VGND VPWR VPWR sky130_fd_sc_hd__decap_3
XPHY_EDGE_ROW_20_Right_20 VGND VGND VPWR VPWR sky130_fd_sc_hd__decap_3
X_679_ _705_/A _680_/B VGND VGND VPWR VPWR _679_/X sky130_fd_sc_hd__and2_4
X_602_ _602_/A _602_/B VGND VGND VPWR VPWR _603_/B sky130_fd_sc_hd__and2_2
X_533_ _530_/Y _534_/B _534_/C VGND VGND VPWR VPWR _533_/X sky130_fd_sc_hd__and3b_2
X_464_ _459_/Y _460_/X _462_/C VGND VGND VPWR VPWR _476_/A sky130_fd_sc_hd__o21bai_2
XFILLER_27_95 VGND VGND VPWR VPWR sky130_fd_sc_hd__decap_3
XFILLER_27_51 VGND VGND VPWR VPWR sky130_fd_sc_hd__decap_3
X_395_ _738_/A _395_/B VGND VGND VPWR VPWR _395_/X sky130_fd_sc_hd__and2_2
XFILLER_4_55 VGND VGND VPWR VPWR sky130_fd_sc_hd__decap_3
XFILLER_13_53 VGND VGND VPWR VPWR sky130_fd_sc_hd__decap_3
X_516_ _515_/A _516_/B _519_/A VGND VGND VPWR VPWR _516_/X sky130_fd_sc_hd__and3b_2
X_447_ _486_/A _449_/B VGND VGND VPWR VPWR _447_/Y sky130_fd_sc_hd__nor2_4
X_378_ _737_/X _391_/B _377_/Y VGND VGND VPWR VPWR _379_/A sky130_fd_sc_hd__o21ai_4
XFILLER_1_9 VGND VGND VPWR VPWR sky130_fd_sc_hd__decap_3
XFILLER_24_85 VGND VGND VPWR VPWR sky130_fd_sc_hd__decap_3
XFILLER_34_9 VGND VGND VPWR VPWR sky130_fd_sc_hd__fill_1
XFILLER_1_12 VGND VGND VPWR VPWR sky130_fd_sc_hd__decap_3
XFILLER_28_128 VGND VGND VPWR VPWR sky130_fd_sc_hd__decap_3
XFILLER_10_76 VGND VGND VPWR VPWR sky130_fd_sc_hd__fill_1
XFILLER_19_96 VGND VGND VPWR VPWR sky130_fd_sc_hd__decap_3
XFILLER_19_63 VGND VGND VPWR VPWR sky130_fd_sc_hd__decap_3
XFILLER_19_128 VGND VGND VPWR VPWR sky130_fd_sc_hd__decap_3
XFILLER_19_106 VGND VGND VPWR VPWR sky130_fd_sc_hd__decap_3
XFILLER_33_186 VGND VGND VPWR VPWR sky130_fd_sc_hd__decap_3
XFILLER_18_194 VGND VGND VPWR VPWR sky130_fd_sc_hd__fill_2
XTAP_TAPCELL_ROW_34_192 VGND VPWR sky130_fd_sc_hd__tapvpwrvgnd_1
XFILLER_24_197 VGND VGND VPWR VPWR sky130_fd_sc_hd__decap_3
XFILLER_24_164 VGND VGND VPWR VPWR sky130_fd_sc_hd__decap_3
XFILLER_21_97 VGND VGND VPWR VPWR sky130_fd_sc_hd__decap_3
XFILLER_15_131 VGND VGND VPWR VPWR sky130_fd_sc_hd__decap_3
X_695_ _697_/C _697_/D VGND VGND VPWR VPWR _695_/X sky130_fd_sc_hd__and2_2
XFILLER_7_77 VGND VGND VPWR VPWR sky130_fd_sc_hd__fill_1
XFILLER_30_145 VGND VGND VPWR VPWR sky130_fd_sc_hd__decap_3
XFILLER_21_167 VGND VGND VPWR VPWR sky130_fd_sc_hd__fill_1
XFILLER_21_134 VGND VGND VPWR VPWR sky130_fd_sc_hd__decap_3
XTAP_TAPCELL_ROW_31_184 VGND VPWR sky130_fd_sc_hd__tapvpwrvgnd_1
XFILLER_12_101 VGND VGND VPWR VPWR sky130_fd_sc_hd__decap_3
X_480_ _480_/A _480_/B VGND VGND VPWR VPWR _480_/Y sky130_fd_sc_hd__nor2_2
XFILLER_16_75 VGND VGND VPWR VPWR sky130_fd_sc_hd__decap_3
XTAP_TAPCELL_ROW_22_151 VGND VPWR sky130_fd_sc_hd__tapvpwrvgnd_1
XFILLER_32_85 VGND VGND VPWR VPWR sky130_fd_sc_hd__decap_3
XFILLER_32_41 VGND VGND VPWR VPWR sky130_fd_sc_hd__fill_2
XFILLER_16_97 VGND VGND VPWR VPWR sky130_fd_sc_hd__fill_1
X_678_ _674_/X _675_/Y input6/X VGND VGND VPWR VPWR _689_/B sky130_fd_sc_hd__o21ai_4
XFILLER_7_160 VGND VGND VPWR VPWR sky130_fd_sc_hd__decap_3
X_601_ _602_/A _602_/B VGND VGND VPWR VPWR _603_/A sky130_fd_sc_hd__nor2_2
XFILLER_27_30 VGND VGND VPWR VPWR sky130_fd_sc_hd__decap_3
X_532_ _671_/B _532_/B VGND VGND VPWR VPWR _534_/B sky130_fd_sc_hd__nand2_2
X_463_ _459_/Y _460_/X _462_/C VGND VGND VPWR VPWR _480_/B sky130_fd_sc_hd__o21ba_2
X_394_ _660_/Y _395_/B VGND VGND VPWR VPWR _416_/C sky130_fd_sc_hd__nand2_2
XTAP_TAPCELL_ROW_10_110 VGND VPWR sky130_fd_sc_hd__tapvpwrvgnd_1
XFILLER_4_141 VGND VGND VPWR VPWR sky130_fd_sc_hd__decap_3
XFILLER_4_130 VGND VGND VPWR VPWR sky130_fd_sc_hd__decap_3
XFILLER_4_185 VGND VGND VPWR VPWR sky130_fd_sc_hd__decap_3
XPHY_EDGE_ROW_18_Left_53 VGND VGND VPWR VPWR sky130_fd_sc_hd__decap_3
XFILLER_13_87 VGND VGND VPWR VPWR sky130_fd_sc_hd__fill_1
XFILLER_13_98 VGND VGND VPWR VPWR sky130_fd_sc_hd__decap_3
Xfanout99 _660_/Y VGND VGND VPWR VPWR _734_/A sky130_fd_sc_hd__buf_8
XFILLER_8_3 VGND VGND VPWR VPWR sky130_fd_sc_hd__fill_1
XFILLER_1_199 VGND VGND VPWR VPWR sky130_fd_sc_hd__decap_3
X_515_ _515_/A _516_/B VGND VGND VPWR VPWR _519_/B sky130_fd_sc_hd__nor2b_2
X_446_ _454_/B _446_/B VGND VGND VPWR VPWR _446_/X sky130_fd_sc_hd__xor2_2
X_377_ _375_/Y _730_/X _374_/Y _373_/C VGND VGND VPWR VPWR _377_/Y sky130_fd_sc_hd__a2bb2oi_2
XPHY_EDGE_ROW_3_Left_38 VGND VGND VPWR VPWR sky130_fd_sc_hd__decap_3
XFILLER_24_97 VGND VGND VPWR VPWR sky130_fd_sc_hd__fill_2
XFILLER_1_24 VGND VGND VPWR VPWR sky130_fd_sc_hd__fill_1
X_429_ _430_/C _430_/D VGND VGND VPWR VPWR _633_/A sky130_fd_sc_hd__nand2_4
Xinput1 A[0] VGND VGND VPWR VPWR _626_/A sky130_fd_sc_hd__clkdlybuf4s25_1
XFILLER_28_118 VGND VGND VPWR VPWR sky130_fd_sc_hd__fill_1
XFILLER_10_88 VGND VGND VPWR VPWR sky130_fd_sc_hd__decap_3
XFILLER_27_162 VGND VGND VPWR VPWR sky130_fd_sc_hd__decap_3
XFILLER_19_75 VGND VGND VPWR VPWR sky130_fd_sc_hd__decap_3
XFILLER_33_198 VGND VGND VPWR VPWR sky130_fd_sc_hd__decap_3
XFILLER_33_132 VGND VGND VPWR VPWR sky130_fd_sc_hd__decap_3
XFILLER_33_121 VGND VGND VPWR VPWR sky130_fd_sc_hd__fill_2
XTAP_TAPCELL_ROW_34_193 VGND VPWR sky130_fd_sc_hd__tapvpwrvgnd_1
XFILLER_24_176 VGND VGND VPWR VPWR sky130_fd_sc_hd__fill_2
XFILLER_21_76 VGND VGND VPWR VPWR sky130_fd_sc_hd__decap_3
X_694_ _682_/Y _683_/Y input4/X VGND VGND VPWR VPWR _697_/D sky130_fd_sc_hd__a21o_2
XPHY_EDGE_ROW_6_Left_41 VGND VGND VPWR VPWR sky130_fd_sc_hd__decap_3
XFILLER_15_143 VGND VGND VPWR VPWR sky130_fd_sc_hd__decap_3
XFILLER_21_146 VGND VGND VPWR VPWR sky130_fd_sc_hd__decap_3
XFILLER_21_113 VGND VGND VPWR VPWR sky130_fd_sc_hd__decap_3
XFILLER_12_113 VGND VGND VPWR VPWR sky130_fd_sc_hd__decap_3
XPHY_EDGE_ROW_32_Left_67 VGND VGND VPWR VPWR sky130_fd_sc_hd__decap_3
XFILLER_16_54 VGND VGND VPWR VPWR sky130_fd_sc_hd__decap_3
XTAP_TAPCELL_ROW_22_152 VGND VPWR sky130_fd_sc_hd__tapvpwrvgnd_1
XFILLER_8_139 VGND VGND VPWR VPWR sky130_fd_sc_hd__fill_1
XFILLER_8_106 VGND VGND VPWR VPWR sky130_fd_sc_hd__fill_1
X_677_ _734_/A _675_/A _676_/Y VGND VGND VPWR VPWR _677_/X sky130_fd_sc_hd__a21o_2
XPHY_EDGE_ROW_9_Right_9 VGND VGND VPWR VPWR sky130_fd_sc_hd__decap_3
XFILLER_7_172 VGND VGND VPWR VPWR sky130_fd_sc_hd__decap_3
Xrebuffer203 _420_/Y VGND VGND VPWR VPWR _635_/A1 sky130_fd_sc_hd__buf_2
XFILLER_5_109 VGND VGND VPWR VPWR sky130_fd_sc_hd__decap_3
X_531_ _671_/B _532_/B VGND VGND VPWR VPWR _531_/X sky130_fd_sc_hd__and2_2
X_600_ _600_/A _600_/B VGND VGND VPWR VPWR _600_/Y sky130_fd_sc_hd__nand2_2
X_462_ _459_/Y _462_/B _462_/C VGND VGND VPWR VPWR _476_/C sky130_fd_sc_hd__nand3b_2
X_393_ _395_/B _738_/A VGND VGND VPWR VPWR _416_/B sky130_fd_sc_hd__nand2b_2
XTAP_TAPCELL_ROW_10_111 VGND VPWR sky130_fd_sc_hd__tapvpwrvgnd_1
XFILLER_4_164 VGND VGND VPWR VPWR sky130_fd_sc_hd__decap_3
XFILLER_4_120 VGND VGND VPWR VPWR sky130_fd_sc_hd__decap_3
XFILLER_4_68 VGND VGND VPWR VPWR sky130_fd_sc_hd__decap_3
XFILLER_4_197 VGND VGND VPWR VPWR sky130_fd_sc_hd__decap_3
X_729_ _738_/A _730_/B VGND VGND VPWR VPWR _731_/C sky130_fd_sc_hd__nand2b_2
XFILLER_13_66 VGND VGND VPWR VPWR sky130_fd_sc_hd__decap_3
XFILLER_1_167 VGND VGND VPWR VPWR sky130_fd_sc_hd__fill_1
XFILLER_1_101 VGND VGND VPWR VPWR sky130_fd_sc_hd__decap_3
X_514_ _530_/A _514_/B VGND VGND VPWR VPWR _516_/B sky130_fd_sc_hd__nand2_2
X_445_ _669_/A _437_/Y _669_/B VGND VGND VPWR VPWR _446_/B sky130_fd_sc_hd__a21bo_2
X_376_ _738_/A _730_/B _375_/Y VGND VGND VPWR VPWR _390_/C sky130_fd_sc_hd__a21o_2
XFILLER_24_76 VGND VGND VPWR VPWR sky130_fd_sc_hd__decap_3
XFILLER_24_32 VGND VGND VPWR VPWR sky130_fd_sc_hd__decap_3
X_428_ _632_/A _630_/A VGND VGND VPWR VPWR _430_/D sky130_fd_sc_hd__nor2_2
X_359_ _660_/Y _662_/Y _357_/X VGND VGND VPWR VPWR _373_/B sky130_fd_sc_hd__o21ai_4
Xinput2 A[10] VGND VGND VPWR VPWR input2/X sky130_fd_sc_hd__clkdlybuf4s25_1
XFILLER_19_87 VGND VGND VPWR VPWR sky130_fd_sc_hd__decap_3
XFILLER_18_141 VGND VGND VPWR VPWR sky130_fd_sc_hd__decap_3
XFILLER_24_144 VGND VGND VPWR VPWR sky130_fd_sc_hd__decap_3
XFILLER_24_133 VGND VGND VPWR VPWR sky130_fd_sc_hd__decap_3
XTAP_TAPCELL_ROW_34_194 VGND VPWR sky130_fd_sc_hd__tapvpwrvgnd_1
XFILLER_21_55 VGND VGND VPWR VPWR sky130_fd_sc_hd__fill_1
XFILLER_21_88 VGND VGND VPWR VPWR sky130_fd_sc_hd__decap_3
X_693_ _679_/X _686_/Y _677_/X _681_/Y _689_/B VGND VGND VPWR VPWR _693_/Y sky130_fd_sc_hd__o2111ai_4
XFILLER_15_111 VGND VGND VPWR VPWR sky130_fd_sc_hd__fill_1
XFILLER_15_122 VGND VGND VPWR VPWR sky130_fd_sc_hd__decap_3
XFILLER_15_155 VGND VGND VPWR VPWR sky130_fd_sc_hd__decap_3
XTAP_TAPCELL_ROW_25_161 VGND VPWR sky130_fd_sc_hd__tapvpwrvgnd_1
XFILLER_30_169 VGND VGND VPWR VPWR sky130_fd_sc_hd__decap_3
XFILLER_7_68 VGND VGND VPWR VPWR sky130_fd_sc_hd__decap_3
XFILLER_7_24 VGND VGND VPWR VPWR sky130_fd_sc_hd__decap_3
XFILLER_21_103 VGND VGND VPWR VPWR sky130_fd_sc_hd__decap_3
XFILLER_21_169 VGND VGND VPWR VPWR sky130_fd_sc_hd__fill_2
XFILLER_21_158 VGND VGND VPWR VPWR sky130_fd_sc_hd__decap_3
XFILLER_21_125 VGND VGND VPWR VPWR sky130_fd_sc_hd__decap_3
Xinput60 B[5] VGND VGND VPWR VPWR _738_/B sky130_fd_sc_hd__clkdlybuf4s25_1
XFILLER_12_125 VGND VGND VPWR VPWR sky130_fd_sc_hd__decap_3
XFILLER_16_88 VGND VGND VPWR VPWR sky130_fd_sc_hd__decap_3
XFILLER_16_66 VGND VGND VPWR VPWR sky130_fd_sc_hd__decap_3
XTAP_TAPCELL_ROW_22_153 VGND VPWR sky130_fd_sc_hd__tapvpwrvgnd_1
XFILLER_20_180 VGND VGND VPWR VPWR sky130_fd_sc_hd__decap_3
X_676_ _675_/A _734_/A input6/X VGND VGND VPWR VPWR _676_/Y sky130_fd_sc_hd__o21bai_2
XTAP_TAPCELL_ROW_13_120 VGND VPWR sky130_fd_sc_hd__tapvpwrvgnd_1
XFILLER_7_151 VGND VGND VPWR VPWR sky130_fd_sc_hd__decap_3
XFILLER_26_206 VGND VGND VPWR VPWR sky130_fd_sc_hd__fill_2
Xrebuffer204 _420_/Y VGND VGND VPWR VPWR _633_/B sky130_fd_sc_hd__buf_6
X_530_ _530_/A _532_/B VGND VGND VPWR VPWR _530_/Y sky130_fd_sc_hd__nor2_4
X_461_ _461_/A _461_/B VGND VGND VPWR VPWR _462_/B sky130_fd_sc_hd__nand2_2
XFILLER_27_98 VGND VGND VPWR VPWR sky130_fd_sc_hd__decap_3
XFILLER_27_54 VGND VGND VPWR VPWR sky130_fd_sc_hd__fill_2
X_392_ _727_/B _725_/X _392_/C _392_/D VGND VGND VPWR VPWR _392_/Y sky130_fd_sc_hd__nand4b_4
XFILLER_4_58 VGND VGND VPWR VPWR sky130_fd_sc_hd__fill_2
XFILLER_4_176 VGND VGND VPWR VPWR sky130_fd_sc_hd__decap_3
X_659_ _623_/Y _624_/Y _620_/A VGND VGND VPWR VPWR _659_/X sky130_fd_sc_hd__a21o_2
X_728_ _730_/B _738_/A VGND VGND VPWR VPWR _731_/B sky130_fd_sc_hd__nand2b_2
XTAP_TAPCELL_ROW_4_90 VGND VPWR sky130_fd_sc_hd__tapvpwrvgnd_1
XFILLER_1_113 VGND VGND VPWR VPWR sky130_fd_sc_hd__decap_3
XFILLER_1_135 VGND VGND VPWR VPWR sky130_fd_sc_hd__decap_3
X_513_ _530_/A _514_/B VGND VGND VPWR VPWR _515_/A sky130_fd_sc_hd__nor2_2
X_444_ _479_/A _455_/A VGND VGND VPWR VPWR _454_/B sky130_fd_sc_hd__nand2_2
X_375_ _738_/A _730_/B _375_/B1 VGND VGND VPWR VPWR _375_/Y sky130_fd_sc_hd__o21ai_2
XFILLER_5_90 VGND VGND VPWR VPWR sky130_fd_sc_hd__fill_1
XFILLER_24_88 VGND VGND VPWR VPWR sky130_fd_sc_hd__decap_3
XFILLER_1_15 VGND VGND VPWR VPWR sky130_fd_sc_hd__decap_3
X_427_ _400_/A _401_/Y _417_/Y VGND VGND VPWR VPWR _630_/A sky130_fd_sc_hd__o21ai_2
X_358_ _738_/A _738_/B _358_/B1 VGND VGND VPWR VPWR _358_/Y sky130_fd_sc_hd__o21ai_2
XPHY_EDGE_ROW_18_Right_18 VGND VGND VPWR VPWR sky130_fd_sc_hd__decap_3
Xinput3 A[11] VGND VGND VPWR VPWR input3/X sky130_fd_sc_hd__clkdlybuf4s25_1
XPHY_EDGE_ROW_27_Right_27 VGND VGND VPWR VPWR sky130_fd_sc_hd__decap_3
XFILLER_19_99 VGND VGND VPWR VPWR sky130_fd_sc_hd__decap_3
XFILLER_19_66 VGND VGND VPWR VPWR sky130_fd_sc_hd__decap_3
XFILLER_19_109 VGND VGND VPWR VPWR sky130_fd_sc_hd__decap_3
XFILLER_18_197 VGND VGND VPWR VPWR sky130_fd_sc_hd__decap_3
XFILLER_33_189 VGND VGND VPWR VPWR sky130_fd_sc_hd__decap_3
XFILLER_24_167 VGND VGND VPWR VPWR sky130_fd_sc_hd__decap_3
XTAP_TAPCELL_ROW_34_195 VGND VPWR sky130_fd_sc_hd__tapvpwrvgnd_1
XFILLER_15_134 VGND VGND VPWR VPWR sky130_fd_sc_hd__decap_3
X_692_ _679_/X _686_/Y _681_/Y VGND VGND VPWR VPWR _692_/Y sky130_fd_sc_hd__o21ai_2
XTAP_TAPCELL_ROW_25_162 VGND VPWR sky130_fd_sc_hd__tapvpwrvgnd_1
XFILLER_30_148 VGND VGND VPWR VPWR sky130_fd_sc_hd__decap_3
Xinput61 B[6] VGND VGND VPWR VPWR _366_/B sky130_fd_sc_hd__clkdlybuf4s25_1
Xinput50 B[25] VGND VGND VPWR VPWR _541_/B sky130_fd_sc_hd__clkdlybuf4s25_1
XFILLER_21_137 VGND VGND VPWR VPWR sky130_fd_sc_hd__decap_3
XFILLER_29_204 VGND VGND VPWR VPWR sky130_fd_sc_hd__decap_3
XFILLER_12_104 VGND VGND VPWR VPWR sky130_fd_sc_hd__decap_3
XPHY_EDGE_ROW_0_Right_0 VGND VGND VPWR VPWR sky130_fd_sc_hd__decap_3
XFILLER_16_78 VGND VGND VPWR VPWR sky130_fd_sc_hd__decap_3
XFILLER_32_88 VGND VGND VPWR VPWR sky130_fd_sc_hd__fill_1
X_675_ _675_/A _734_/A VGND VGND VPWR VPWR _675_/Y sky130_fd_sc_hd__nor2_2
XTAP_TAPCELL_ROW_13_121 VGND VPWR sky130_fd_sc_hd__tapvpwrvgnd_1
XFILLER_7_163 VGND VGND VPWR VPWR sky130_fd_sc_hd__decap_3
XFILLER_7_130 VGND VGND VPWR VPWR sky130_fd_sc_hd__decap_3
Xrebuffer205 _413_/Y VGND VGND VPWR VPWR _629_/C1 sky130_fd_sc_hd__buf_2
X_460_ _486_/A _461_/B VGND VGND VPWR VPWR _460_/X sky130_fd_sc_hd__and2_2
X_391_ _391_/A _391_/B VGND VGND VPWR VPWR _431_/B sky130_fd_sc_hd__nor2_4
XFILLER_17_207 VGND VGND VPWR VPWR sky130_fd_sc_hd__fill_1
XFILLER_4_188 VGND VGND VPWR VPWR sky130_fd_sc_hd__fill_1
XFILLER_4_144 VGND VGND VPWR VPWR sky130_fd_sc_hd__decap_3
XFILLER_4_133 VGND VGND VPWR VPWR sky130_fd_sc_hd__decap_3
XFILLER_4_111 VGND VGND VPWR VPWR sky130_fd_sc_hd__decap_3
X_727_ _727_/A _727_/B VGND VGND VPWR VPWR _727_/Y sky130_fd_sc_hd__nor2_4
X_589_ _588_/A _588_/B _581_/A VGND VGND VPWR VPWR _598_/B sky130_fd_sc_hd__a21o_2
X_658_ _696_/Y _658_/B VGND VGND VPWR VPWR _658_/X sky130_fd_sc_hd__xor2_2
XFILLER_13_57 VGND VGND VPWR VPWR sky130_fd_sc_hd__decap_3
X_512_ _524_/A1 _499_/Y _505_/B _503_/Y VGND VGND VPWR VPWR _521_/B sky130_fd_sc_hd__a31oi_2
X_443_ _660_/Y _440_/B _442_/Y VGND VGND VPWR VPWR _455_/A sky130_fd_sc_hd__o21ai_2
X_374_ _353_/Y _357_/X _365_/X _369_/Y VGND VGND VPWR VPWR _374_/Y sky130_fd_sc_hd__o2bb2ai_2
X_426_ _395_/X _397_/Y _416_/Y VGND VGND VPWR VPWR _632_/A sky130_fd_sc_hd__o21ai_2
X_357_ _738_/B _369_/A1 _358_/B1 VGND VGND VPWR VPWR _357_/X sky130_fd_sc_hd__o21a_4
Xinput4 A[12] VGND VGND VPWR VPWR input4/X sky130_fd_sc_hd__clkdlybuf4s25_1
XFILLER_27_165 VGND VGND VPWR VPWR sky130_fd_sc_hd__decap_3
XFILLER_19_78 VGND VGND VPWR VPWR sky130_fd_sc_hd__decap_3
XFILLER_27_198 VGND VGND VPWR VPWR sky130_fd_sc_hd__fill_2
XTAP_TAPCELL_ROW_28_171 VGND VPWR sky130_fd_sc_hd__tapvpwrvgnd_1
XFILLER_33_135 VGND VGND VPWR VPWR sky130_fd_sc_hd__fill_1
XFILLER_18_165 VGND VGND VPWR VPWR sky130_fd_sc_hd__decap_3
X_409_ _409_/A _627_/S VGND VGND VPWR VPWR _409_/Y sky130_fd_sc_hd__nor2_2
XTAP_TAPCELL_ROW_34_196 VGND VPWR sky130_fd_sc_hd__tapvpwrvgnd_1
XFILLER_21_79 VGND VGND VPWR VPWR sky130_fd_sc_hd__decap_3
XFILLER_15_102 VGND VGND VPWR VPWR sky130_fd_sc_hd__decap_3
XFILLER_15_113 VGND VGND VPWR VPWR sky130_fd_sc_hd__decap_3
XFILLER_15_146 VGND VGND VPWR VPWR sky130_fd_sc_hd__decap_3
X_691_ _676_/Y _674_/X _689_/B VGND VGND VPWR VPWR _691_/Y sky130_fd_sc_hd__o21ai_2
XTAP_TAPCELL_ROW_25_163 VGND VPWR sky130_fd_sc_hd__tapvpwrvgnd_1
XTAP_TAPCELL_ROW_16_130 VGND VPWR sky130_fd_sc_hd__tapvpwrvgnd_1
XFILLER_21_149 VGND VGND VPWR VPWR sky130_fd_sc_hd__decap_3
XFILLER_21_116 VGND VGND VPWR VPWR sky130_fd_sc_hd__decap_3
Xinput40 B[16] VGND VGND VPWR VPWR _665_/A sky130_fd_sc_hd__clkdlybuf4s25_1
Xinput62 B[7] VGND VGND VPWR VPWR _730_/B sky130_fd_sc_hd__clkdlybuf4s25_1
Xinput51 B[26] VGND VGND VPWR VPWR _552_/B sky130_fd_sc_hd__clkdlybuf4s25_1
XFILLER_16_57 VGND VGND VPWR VPWR sky130_fd_sc_hd__decap_3
XFILLER_12_116 VGND VGND VPWR VPWR sky130_fd_sc_hd__decap_3
XFILLER_32_78 VGND VGND VPWR VPWR sky130_fd_sc_hd__fill_1
XFILLER_20_171 VGND VGND VPWR VPWR sky130_fd_sc_hd__fill_1
X_674_ _734_/A _675_/A VGND VGND VPWR VPWR _674_/X sky130_fd_sc_hd__and2_4
XFILLER_7_175 VGND VGND VPWR VPWR sky130_fd_sc_hd__fill_1
XFILLER_21_3 VGND VGND VPWR VPWR sky130_fd_sc_hd__decap_3
Xrebuffer206 _404_/A VGND VGND VPWR VPWR _665_/B sky130_fd_sc_hd__buf_2
X_390_ _731_/Y _737_/X _390_/C _390_/D VGND VGND VPWR VPWR _391_/A sky130_fd_sc_hd__nand4_2
XFILLER_4_167 VGND VGND VPWR VPWR sky130_fd_sc_hd__decap_3
XFILLER_4_16 VGND VGND VPWR VPWR sky130_fd_sc_hd__decap_3
X_657_ _693_/Y _651_/Y _689_/B _689_/C VGND VGND VPWR VPWR _658_/B sky130_fd_sc_hd__o211a_2
X_726_ _714_/X _715_/Y _722_/X _716_/Y _724_/Y VGND VGND VPWR VPWR _727_/A sky130_fd_sc_hd__o2111ai_4
X_588_ _588_/A _588_/B VGND VGND VPWR VPWR _609_/A sky130_fd_sc_hd__nand2_2
XFILLER_13_69 VGND VGND VPWR VPWR sky130_fd_sc_hd__decap_3
XFILLER_1_104 VGND VGND VPWR VPWR sky130_fd_sc_hd__fill_1
X_511_ _511_/A _511_/B VGND VGND VPWR VPWR _521_/A sky130_fd_sc_hd__nand2_4
X_442_ _660_/Y _440_/B _441_/C VGND VGND VPWR VPWR _442_/Y sky130_fd_sc_hd__a21oi_2
X_373_ _373_/A _373_/B _373_/C _373_/D VGND VGND VPWR VPWR _391_/B sky130_fd_sc_hd__nand4_4
XFILLER_0_192 VGND VGND VPWR VPWR sky130_fd_sc_hd__decap_3
X_709_ _735_/B _705_/B _708_/Y VGND VGND VPWR VPWR _711_/D sky130_fd_sc_hd__a21o_4
XFILLER_5_70 VGND VGND VPWR VPWR sky130_fd_sc_hd__decap_3
XFILLER_24_79 VGND VGND VPWR VPWR sky130_fd_sc_hd__decap_3
XFILLER_24_35 VGND VGND VPWR VPWR sky130_fd_sc_hd__fill_2
XPHY_EDGE_ROW_23_Left_58 VGND VGND VPWR VPWR sky130_fd_sc_hd__decap_3
XFILLER_14_90 VGND VGND VPWR VPWR sky130_fd_sc_hd__decap_3
X_425_ _425_/A _425_/B VGND VGND VPWR VPWR _430_/C sky130_fd_sc_hd__nor2_4
X_356_ _660_/Y _738_/B VGND VGND VPWR VPWR _361_/C sky130_fd_sc_hd__nand2_2
Xinput5 A[13] VGND VGND VPWR VPWR input5/X sky130_fd_sc_hd__clkdlybuf4s25_1
XFILLER_19_57 VGND VGND VPWR VPWR sky130_fd_sc_hd__decap_3
XFILLER_18_133 VGND VGND VPWR VPWR sky130_fd_sc_hd__decap_3
X_408_ _439_/A _627_/S VGND VGND VPWR VPWR _408_/X sky130_fd_sc_hd__and2_2
XTAP_TAPCELL_ROW_28_172 VGND VPWR sky130_fd_sc_hd__tapvpwrvgnd_1
XFILLER_33_158 VGND VGND VPWR VPWR sky130_fd_sc_hd__fill_2
XFILLER_18_144 VGND VGND VPWR VPWR sky130_fd_sc_hd__fill_1
XFILLER_2_93 VGND VGND VPWR VPWR sky130_fd_sc_hd__decap_3
XTAP_TAPCELL_ROW_34_197 VGND VPWR sky130_fd_sc_hd__tapvpwrvgnd_1
XFILLER_32_180 VGND VGND VPWR VPWR sky130_fd_sc_hd__decap_3
XFILLER_24_158 VGND VGND VPWR VPWR sky130_fd_sc_hd__decap_3
XFILLER_24_147 VGND VGND VPWR VPWR sky130_fd_sc_hd__decap_3
XFILLER_24_136 VGND VGND VPWR VPWR sky130_fd_sc_hd__decap_3
XFILLER_21_36 VGND VGND VPWR VPWR sky130_fd_sc_hd__decap_3
X_690_ _697_/B _690_/B VGND VGND VPWR VPWR _690_/Y sky130_fd_sc_hd__nand2_2
XFILLER_15_125 VGND VGND VPWR VPWR sky130_fd_sc_hd__decap_3
XFILLER_15_158 VGND VGND VPWR VPWR sky130_fd_sc_hd__decap_3
XFILLER_15_169 VGND VGND VPWR VPWR sky130_fd_sc_hd__fill_1
XFILLER_30_117 VGND VGND VPWR VPWR sky130_fd_sc_hd__fill_2
XFILLER_23_180 VGND VGND VPWR VPWR sky130_fd_sc_hd__decap_3
XTAP_TAPCELL_ROW_16_131 VGND VPWR sky130_fd_sc_hd__tapvpwrvgnd_1
XPHY_EDGE_ROW_26_Left_61 VGND VGND VPWR VPWR sky130_fd_sc_hd__decap_3
XFILLER_21_128 VGND VGND VPWR VPWR sky130_fd_sc_hd__decap_3
XFILLER_21_106 VGND VGND VPWR VPWR sky130_fd_sc_hd__decap_3
Xinput30 A[7] VGND VGND VPWR VPWR _375_/B1 sky130_fd_sc_hd__clkdlybuf4s25_1
Xinput41 B[17] VGND VGND VPWR VPWR _440_/B sky130_fd_sc_hd__clkdlybuf4s25_1
Xinput63 B[8] VGND VGND VPWR VPWR _719_/B sky130_fd_sc_hd__clkdlybuf4s25_1
Xinput52 B[27] VGND VGND VPWR VPWR _568_/B sky130_fd_sc_hd__clkdlybuf4s25_1
XPHY_EDGE_ROW_10_Left_45 VGND VGND VPWR VPWR sky130_fd_sc_hd__decap_3
XFILLER_16_69 VGND VGND VPWR VPWR sky130_fd_sc_hd__decap_3
XFILLER_12_128 VGND VGND VPWR VPWR sky130_fd_sc_hd__decap_3
XFILLER_20_150 VGND VGND VPWR VPWR sky130_fd_sc_hd__decap_3
X_673_ input7/X _673_/B _673_/C VGND VGND VPWR VPWR _697_/B sky130_fd_sc_hd__nand3b_2
XFILLER_7_154 VGND VGND VPWR VPWR sky130_fd_sc_hd__decap_3
XFILLER_7_121 VGND VGND VPWR VPWR sky130_fd_sc_hd__decap_3
XFILLER_8_92 VGND VGND VPWR VPWR sky130_fd_sc_hd__decap_3
XFILLER_4_179 VGND VGND VPWR VPWR sky130_fd_sc_hd__decap_3
X_587_ _526_/Y _582_/X _584_/X VGND VGND VPWR VPWR _588_/B sky130_fd_sc_hd__a21oi_4
X_656_ _691_/Y _656_/B VGND VGND VPWR VPWR _656_/Y sky130_fd_sc_hd__xnor2_2
X_725_ _714_/X _715_/Y _716_/Y _724_/Y _722_/X VGND VGND VPWR VPWR _725_/X sky130_fd_sc_hd__o2111a_2
XFILLER_17_90 VGND VGND VPWR VPWR sky130_fd_sc_hd__decap_3
XFILLER_3_190 VGND VGND VPWR VPWR sky130_fd_sc_hd__decap_3
X_510_ _510_/A _510_/B _523_/B VGND VGND VPWR VPWR _511_/A sky130_fd_sc_hd__and3_2
X_441_ _441_/A _441_/B _441_/C VGND VGND VPWR VPWR _479_/A sky130_fd_sc_hd__nand3_2
X_372_ _636_/A _638_/A VGND VGND VPWR VPWR _392_/C sky130_fd_sc_hd__nor2_2
X_639_ _373_/C _374_/Y _636_/B _391_/B VGND VGND VPWR VPWR _640_/B sky130_fd_sc_hd__o2bb2a_2
X_708_ _705_/B _705_/A input3/X VGND VGND VPWR VPWR _708_/Y sky130_fd_sc_hd__o21ai_4
XFILLER_24_58 VGND VGND VPWR VPWR sky130_fd_sc_hd__fill_1
XFILLER_1_18 VGND VGND VPWR VPWR sky130_fd_sc_hd__decap_3
X_424_ _627_/S _410_/Y _365_/A _423_/Y VGND VGND VPWR VPWR _425_/A sky130_fd_sc_hd__o211ai_2
X_355_ _662_/Y _355_/B VGND VGND VPWR VPWR _361_/B sky130_fd_sc_hd__nand2_2
Xinput6 A[14] VGND VGND VPWR VPWR input6/X sky130_fd_sc_hd__clkdlybuf4s25_1
XFILLER_10_49 VGND VGND VPWR VPWR sky130_fd_sc_hd__decap_3
XFILLER_27_101 VGND VGND VPWR VPWR sky130_fd_sc_hd__decap_3
XFILLER_19_69 VGND VGND VPWR VPWR sky130_fd_sc_hd__decap_3
XFILLER_27_156 VGND VGND VPWR VPWR sky130_fd_sc_hd__decap_3
XPHY_EDGE_ROW_14_Right_14 VGND VGND VPWR VPWR sky130_fd_sc_hd__decap_3
XPHY_EDGE_ROW_23_Right_23 VGND VGND VPWR VPWR sky130_fd_sc_hd__decap_3
XFILLER_18_112 VGND VGND VPWR VPWR sky130_fd_sc_hd__decap_3
X_407_ _404_/A _404_/B _406_/Y VGND VGND VPWR VPWR _407_/X sky130_fd_sc_hd__a21o_4
XTAP_TAPCELL_ROW_28_173 VGND VPWR sky130_fd_sc_hd__tapvpwrvgnd_1
XPHY_EDGE_ROW_32_Right_32 VGND VGND VPWR VPWR sky130_fd_sc_hd__decap_3
XFILLER_25_90 VGND VGND VPWR VPWR sky130_fd_sc_hd__decap_3
XTAP_TAPCELL_ROW_19_140 VGND VPWR sky130_fd_sc_hd__tapvpwrvgnd_1
XTAP_TAPCELL_ROW_34_198 VGND VPWR sky130_fd_sc_hd__tapvpwrvgnd_1
XFILLER_32_192 VGND VGND VPWR VPWR sky130_fd_sc_hd__decap_3
XFILLER_21_15 VGND VGND VPWR VPWR sky130_fd_sc_hd__decap_3
XFILLER_15_137 VGND VGND VPWR VPWR sky130_fd_sc_hd__decap_3
XFILLER_11_70 VGND VGND VPWR VPWR sky130_fd_sc_hd__decap_3
XTAP_TAPCELL_ROW_16_132 VGND VPWR sky130_fd_sc_hd__tapvpwrvgnd_1
Xinput20 A[27] VGND VGND VPWR VPWR input20/X sky130_fd_sc_hd__clkdlybuf4s25_1
Xinput31 A[8] VGND VGND VPWR VPWR _720_/B1 sky130_fd_sc_hd__clkdlybuf4s25_1
Xinput42 B[18] VGND VGND VPWR VPWR _449_/B sky130_fd_sc_hd__clkdlybuf4s25_1
Xinput64 B[9] VGND VGND VPWR VPWR _714_/B sky130_fd_sc_hd__clkdlybuf4s25_1
Xinput53 B[28] VGND VGND VPWR VPWR _577_/B sky130_fd_sc_hd__clkdlybuf4s25_1
XFILLER_29_207 VGND VGND VPWR VPWR sky130_fd_sc_hd__fill_1
XFILLER_12_107 VGND VGND VPWR VPWR sky130_fd_sc_hd__decap_3
XFILLER_32_58 VGND VGND VPWR VPWR sky130_fd_sc_hd__decap_3
XFILLER_20_162 VGND VGND VPWR VPWR sky130_fd_sc_hd__decap_3
XTAP_TAPCELL_ROW_7_100 VGND VPWR sky130_fd_sc_hd__tapvpwrvgnd_1
X_672_ _673_/B _673_/C input7/X VGND VGND VPWR VPWR _697_/A sky130_fd_sc_hd__a21bo_2
XFILLER_11_173 VGND VGND VPWR VPWR sky130_fd_sc_hd__fill_1
XFILLER_7_166 VGND VGND VPWR VPWR sky130_fd_sc_hd__fill_2
XFILLER_7_133 VGND VGND VPWR VPWR sky130_fd_sc_hd__decap_3
XFILLER_22_91 VGND VGND VPWR VPWR sky130_fd_sc_hd__decap_3
XFILLER_8_82 VGND VGND VPWR VPWR sky130_fd_sc_hd__fill_2
XPHY_EDGE_ROW_4_Right_4 VGND VGND VPWR VPWR sky130_fd_sc_hd__decap_3
XFILLER_4_29 VGND VGND VPWR VPWR sky130_fd_sc_hd__fill_2
XFILLER_4_147 VGND VGND VPWR VPWR sky130_fd_sc_hd__decap_3
XFILLER_4_136 VGND VGND VPWR VPWR sky130_fd_sc_hd__decap_3
XFILLER_4_114 VGND VGND VPWR VPWR sky130_fd_sc_hd__decap_3
X_724_ _719_/Y _718_/X _720_/B1 VGND VGND VPWR VPWR _724_/Y sky130_fd_sc_hd__o21bai_4
X_586_ _432_/Y _436_/Y _435_/X _585_/Y VGND VGND VPWR VPWR _588_/A sky130_fd_sc_hd__o211ai_4
X_655_ _681_/Y _687_/Y _692_/Y _651_/Y VGND VGND VPWR VPWR _656_/B sky130_fd_sc_hd__o2bb2ai_2
X_440_ _660_/A _440_/B VGND VGND VPWR VPWR _441_/B sky130_fd_sc_hd__nand2_2
X_371_ _365_/X _369_/Y _373_/C VGND VGND VPWR VPWR _638_/A sky130_fd_sc_hd__o21ai_2
X_707_ _705_/X _704_/Y input3/X VGND VGND VPWR VPWR _711_/A sky130_fd_sc_hd__o21bai_4
XFILLER_28_90 VGND VGND VPWR VPWR sky130_fd_sc_hd__decap_3
X_569_ _569_/A _569_/B input20/X VGND VGND VPWR VPWR _583_/C sky130_fd_sc_hd__or3b_4
X_638_ _638_/A _638_/B VGND VGND VPWR VPWR _638_/Y sky130_fd_sc_hd__xnor2_2
X_423_ _408_/X _409_/Y _626_/A VGND VGND VPWR VPWR _423_/Y sky130_fd_sc_hd__o21bai_2
X_354_ _738_/B _660_/Y VGND VGND VPWR VPWR _354_/Y sky130_fd_sc_hd__nor2_2
XFILLER_14_81 VGND VGND VPWR VPWR sky130_fd_sc_hd__decap_3
Xinput7 A[15] VGND VGND VPWR VPWR input7/X sky130_fd_sc_hd__clkdlybuf4s25_1
XFILLER_4_3 VGND VGND VPWR VPWR sky130_fd_sc_hd__fill_2
XTAP_TAPCELL_ROW_28_174 VGND VPWR sky130_fd_sc_hd__tapvpwrvgnd_1
XFILLER_18_168 VGND VGND VPWR VPWR sky130_fd_sc_hd__decap_3
XFILLER_18_124 VGND VGND VPWR VPWR sky130_fd_sc_hd__decap_3
X_406_ _404_/B _404_/A _663_/A VGND VGND VPWR VPWR _406_/Y sky130_fd_sc_hd__o21ai_4
XFILLER_2_40 VGND VGND VPWR VPWR sky130_fd_sc_hd__fill_1
XTAP_TAPCELL_ROW_19_141 VGND VPWR sky130_fd_sc_hd__tapvpwrvgnd_1
XFILLER_15_105 VGND VGND VPWR VPWR sky130_fd_sc_hd__decap_3
XFILLER_15_116 VGND VGND VPWR VPWR sky130_fd_sc_hd__decap_3
XFILLER_15_149 VGND VGND VPWR VPWR sky130_fd_sc_hd__decap_3
Xinput10 A[18] VGND VGND VPWR VPWR _450_/C sky130_fd_sc_hd__clkdlybuf4s25_1
Xinput21 A[28] VGND VGND VPWR VPWR input21/X sky130_fd_sc_hd__clkdlybuf4s25_1
Xinput32 A[9] VGND VGND VPWR VPWR _715_/B1 sky130_fd_sc_hd__clkdlybuf4s25_1
Xinput43 B[19] VGND VGND VPWR VPWR _461_/B sky130_fd_sc_hd__clkdlybuf4s25_1
Xinput54 B[29] VGND VGND VPWR VPWR _593_/B sky130_fd_sc_hd__clkdlybuf4s25_1
XFILLER_21_119 VGND VGND VPWR VPWR sky130_fd_sc_hd__decap_3
Xinput65 sub VGND VGND VPWR VPWR input65/X sky130_fd_sc_hd__buf_8
XFILLER_12_119 VGND VGND VPWR VPWR sky130_fd_sc_hd__decap_3
XFILLER_32_15 VGND VGND VPWR VPWR sky130_fd_sc_hd__fill_1
XFILLER_20_141 VGND VGND VPWR VPWR sky130_fd_sc_hd__decap_3
XFILLER_20_130 VGND VGND VPWR VPWR sky130_fd_sc_hd__decap_3
XTAP_TAPCELL_ROW_30_180 VGND VPWR sky130_fd_sc_hd__tapvpwrvgnd_1
X_671_ _670_/B _671_/B VGND VGND VPWR VPWR _673_/C sky130_fd_sc_hd__nand2b_2
XFILLER_11_141 VGND VGND VPWR VPWR sky130_fd_sc_hd__decap_3
XFILLER_7_145 VGND VGND VPWR VPWR sky130_fd_sc_hd__decap_3
XFILLER_22_81 VGND VGND VPWR VPWR sky130_fd_sc_hd__decap_3
XFILLER_34_200 VGND VGND VPWR VPWR sky130_fd_sc_hd__decap_3
XFILLER_21_6 VGND VGND VPWR VPWR sky130_fd_sc_hd__fill_1
XFILLER_27_48 VGND VGND VPWR VPWR sky130_fd_sc_hd__decap_3
X_654_ _692_/Y _654_/B VGND VGND VPWR VPWR _654_/Y sky130_fd_sc_hd__xnor2_2
X_723_ _718_/X _719_/Y _720_/B1 VGND VGND VPWR VPWR _723_/X sky130_fd_sc_hd__o21ba_2
X_585_ _585_/A _585_/B _585_/C VGND VGND VPWR VPWR _585_/Y sky130_fd_sc_hd__nor3_4
XFILLER_17_81 VGND VGND VPWR VPWR sky130_fd_sc_hd__decap_3
XFILLER_3_181 VGND VGND VPWR VPWR sky130_fd_sc_hd__decap_3
X_370_ _370_/A _370_/B VGND VGND VPWR VPWR _373_/D sky130_fd_sc_hd__nand2_4
XFILLER_0_151 VGND VGND VPWR VPWR sky130_fd_sc_hd__decap_3
XFILLER_0_195 VGND VGND VPWR VPWR sky130_fd_sc_hd__fill_1
X_637_ _373_/B _636_/B _360_/Y _354_/Y VGND VGND VPWR VPWR _638_/B sky130_fd_sc_hd__o2bb2a_2
X_706_ _704_/Y _705_/X input3/X VGND VGND VPWR VPWR _706_/X sky130_fd_sc_hd__o21ba_2
X_568_ _602_/A _568_/B VGND VGND VPWR VPWR _569_/B sky130_fd_sc_hd__and2_2
X_499_ _486_/X _490_/Y _472_/Y VGND VGND VPWR VPWR _499_/Y sky130_fd_sc_hd__o21ai_2
XFILLER_5_73 VGND VGND VPWR VPWR sky130_fd_sc_hd__fill_1
XFILLER_5_51 VGND VGND VPWR VPWR sky130_fd_sc_hd__decap_3
XFILLER_24_27 VGND VGND VPWR VPWR sky130_fd_sc_hd__fill_1
X_422_ _406_/Y _404_/X _413_/A VGND VGND VPWR VPWR _425_/B sky130_fd_sc_hd__o21ai_4
X_353_ _355_/B _738_/B VGND VGND VPWR VPWR _353_/Y sky130_fd_sc_hd__nand2_2
XFILLER_14_93 VGND VGND VPWR VPWR sky130_fd_sc_hd__decap_3
XFILLER_30_92 VGND VGND VPWR VPWR sky130_fd_sc_hd__decap_3
Xinput8 A[16] VGND VGND VPWR VPWR _668_/A sky130_fd_sc_hd__clkdlybuf4s25_1
XFILLER_19_38 VGND VGND VPWR VPWR sky130_fd_sc_hd__fill_1
XFILLER_26_180 VGND VGND VPWR VPWR sky130_fd_sc_hd__decap_3
XFILLER_18_136 VGND VGND VPWR VPWR sky130_fd_sc_hd__decap_3
X_405_ _663_/Y _405_/B _405_/C VGND VGND VPWR VPWR _413_/A sky130_fd_sc_hd__nand3_4
XFILLER_25_81 VGND VGND VPWR VPWR sky130_fd_sc_hd__decap_3
XTAP_TAPCELL_ROW_19_142 VGND VPWR sky130_fd_sc_hd__tapvpwrvgnd_1
XFILLER_32_183 VGND VGND VPWR VPWR sky130_fd_sc_hd__decap_3
XFILLER_24_139 VGND VGND VPWR VPWR sky130_fd_sc_hd__fill_1
XFILLER_15_128 VGND VGND VPWR VPWR sky130_fd_sc_hd__decap_3
XFILLER_11_50 VGND VGND VPWR VPWR sky130_fd_sc_hd__decap_3
XFILLER_11_94 VGND VGND VPWR VPWR sky130_fd_sc_hd__decap_3
XFILLER_21_109 VGND VGND VPWR VPWR sky130_fd_sc_hd__decap_3
Xinput11 A[19] VGND VGND VPWR VPWR _462_/C sky130_fd_sc_hd__clkdlybuf4s25_1
Xinput22 A[29] VGND VGND VPWR VPWR input22/X sky130_fd_sc_hd__clkdlybuf4s25_1
Xinput33 B[0] VGND VGND VPWR VPWR _627_/S sky130_fd_sc_hd__dlymetal6s4s_1
Xinput44 B[1] VGND VGND VPWR VPWR _404_/B sky130_fd_sc_hd__clkdlybuf4s25_1
Xinput55 B[2] VGND VGND VPWR VPWR _399_/B sky130_fd_sc_hd__clkdlybuf4s25_1
XFILLER_20_153 VGND VGND VPWR VPWR sky130_fd_sc_hd__decap_3
XTAP_TAPCELL_ROW_30_181 VGND VPWR sky130_fd_sc_hd__tapvpwrvgnd_1
XFILLER_20_197 VGND VGND VPWR VPWR sky130_fd_sc_hd__decap_3
X_670_ _670_/A _670_/B VGND VGND VPWR VPWR _673_/B sky130_fd_sc_hd__nand2_2
XFILLER_7_157 VGND VGND VPWR VPWR sky130_fd_sc_hd__decap_3
XFILLER_7_124 VGND VGND VPWR VPWR sky130_fd_sc_hd__decap_3
XFILLER_7_113 VGND VGND VPWR VPWR sky130_fd_sc_hd__fill_1
XPHY_EDGE_ROW_14_Left_49 VGND VGND VPWR VPWR sky130_fd_sc_hd__decap_3
XFILLER_8_95 VGND VGND VPWR VPWR sky130_fd_sc_hd__fill_2
XFILLER_27_27 VGND VGND VPWR VPWR sky130_fd_sc_hd__decap_3
XFILLER_4_127 VGND VGND VPWR VPWR sky130_fd_sc_hd__decap_3
X_653_ input4/X _682_/Y _683_/Y _652_/B _695_/X VGND VGND VPWR VPWR _654_/B sky130_fd_sc_hd__a32o_2
X_722_ _719_/A _719_/B _720_/Y VGND VGND VPWR VPWR _722_/X sky130_fd_sc_hd__a21o_4
X_584_ _566_/A _566_/B _583_/D _570_/Y VGND VGND VPWR VPWR _584_/X sky130_fd_sc_hd__a31o_2
XFILLER_17_60 VGND VGND VPWR VPWR sky130_fd_sc_hd__decap_3
XFILLER_33_81 VGND VGND VPWR VPWR sky130_fd_sc_hd__decap_3
XFILLER_12_3 VGND VGND VPWR VPWR sky130_fd_sc_hd__decap_3
XFILLER_3_193 VGND VGND VPWR VPWR sky130_fd_sc_hd__fill_1
XFILLER_3_160 VGND VGND VPWR VPWR sky130_fd_sc_hd__decap_3
XFILLER_0_141 VGND VGND VPWR VPWR sky130_fd_sc_hd__fill_2
X_567_ _602_/A _568_/B VGND VGND VPWR VPWR _569_/A sky130_fd_sc_hd__nor2_2
X_636_ _636_/A _636_/B VGND VGND VPWR VPWR _636_/X sky130_fd_sc_hd__xor2_2
X_705_ _705_/A _705_/B VGND VGND VPWR VPWR _705_/X sky130_fd_sc_hd__and2_4
XFILLER_28_70 VGND VGND VPWR VPWR sky130_fd_sc_hd__decap_3
X_498_ _486_/X _490_/Y _472_/Y VGND VGND VPWR VPWR _498_/X sky130_fd_sc_hd__o21a_2
XPHY_EDGE_ROW_17_Left_52 VGND VGND VPWR VPWR sky130_fd_sc_hd__decap_3
X_421_ _395_/X _397_/Y _419_/Y _414_/Y VGND VGND VPWR VPWR _431_/A sky130_fd_sc_hd__o22ai_2
XFILLER_14_50 VGND VGND VPWR VPWR sky130_fd_sc_hd__decap_3
XFILLER_14_72 VGND VGND VPWR VPWR sky130_fd_sc_hd__decap_3
XFILLER_30_71 VGND VGND VPWR VPWR sky130_fd_sc_hd__decap_3
Xinput9 A[17] VGND VGND VPWR VPWR _441_/C sky130_fd_sc_hd__clkdlybuf4s25_1
X_619_ _618_/A _618_/B input25/X VGND VGND VPWR VPWR _620_/B sky130_fd_sc_hd__o21ba_2
XFILLER_27_159 VGND VGND VPWR VPWR sky130_fd_sc_hd__decap_3
XFILLER_27_104 VGND VGND VPWR VPWR sky130_fd_sc_hd__fill_1
XPHY_EDGE_ROW_2_Left_37 VGND VGND VPWR VPWR sky130_fd_sc_hd__decap_3
X_404_ _404_/A _404_/B VGND VGND VPWR VPWR _404_/X sky130_fd_sc_hd__and2_2
XFILLER_25_60 VGND VGND VPWR VPWR sky130_fd_sc_hd__decap_3
XFILLER_25_93 VGND VGND VPWR VPWR sky130_fd_sc_hd__decap_3
XPHY_EDGE_ROW_10_Right_10 VGND VGND VPWR VPWR sky130_fd_sc_hd__decap_3
XFILLER_32_195 VGND VGND VPWR VPWR sky130_fd_sc_hd__fill_1
XTAP_TAPCELL_ROW_33_190 VGND VPWR sky130_fd_sc_hd__tapvpwrvgnd_1
XFILLER_11_73 VGND VGND VPWR VPWR sky130_fd_sc_hd__fill_2
XFILLER_14_195 VGND VGND VPWR VPWR sky130_fd_sc_hd__fill_1
Xinput12 A[1] VGND VGND VPWR VPWR _663_/A sky130_fd_sc_hd__clkdlybuf4s25_1
Xinput23 A[2] VGND VGND VPWR VPWR _631_/A1 sky130_fd_sc_hd__clkdlybuf4s25_1
Xinput34 B[10] VGND VGND VPWR VPWR _699_/B sky130_fd_sc_hd__clkdlybuf4s25_1
Xinput45 B[20] VGND VGND VPWR VPWR _471_/B sky130_fd_sc_hd__clkdlybuf4s25_1
Xinput56 B[30] VGND VGND VPWR VPWR _602_/B sky130_fd_sc_hd__clkdlybuf4s25_1
XFILLER_20_165 VGND VGND VPWR VPWR sky130_fd_sc_hd__decap_3
XFILLER_20_121 VGND VGND VPWR VPWR sky130_fd_sc_hd__decap_3
XPHY_EDGE_ROW_5_Left_40 VGND VGND VPWR VPWR sky130_fd_sc_hd__decap_3
XFILLER_7_169 VGND VGND VPWR VPWR sky130_fd_sc_hd__decap_3
XFILLER_22_94 VGND VGND VPWR VPWR sky130_fd_sc_hd__decap_3
XTAP_TAPCELL_ROW_10_108 VGND VPWR sky130_fd_sc_hd__tapvpwrvgnd_1
XFILLER_4_139 VGND VGND VPWR VPWR sky130_fd_sc_hd__fill_1
XFILLER_4_117 VGND VGND VPWR VPWR sky130_fd_sc_hd__decap_3
XPHY_EDGE_ROW_31_Left_66 VGND VGND VPWR VPWR sky130_fd_sc_hd__decap_3
X_583_ _583_/A _583_/B _583_/C _583_/D VGND VGND VPWR VPWR _585_/A sky130_fd_sc_hd__nand4_2
X_652_ _695_/X _652_/B VGND VGND VPWR VPWR _652_/X sky130_fd_sc_hd__xor2_2
X_721_ _719_/A _719_/B _720_/Y VGND VGND VPWR VPWR _721_/Y sky130_fd_sc_hd__a21oi_2
XFILLER_17_72 VGND VGND VPWR VPWR sky130_fd_sc_hd__decap_3
XFILLER_33_60 VGND VGND VPWR VPWR sky130_fd_sc_hd__decap_3
XPHY_EDGE_ROW_8_Right_8 VGND VGND VPWR VPWR sky130_fd_sc_hd__decap_3
XFILLER_13_205 VGND VGND VPWR VPWR sky130_fd_sc_hd__decap_3
XFILLER_0_197 VGND VGND VPWR VPWR sky130_fd_sc_hd__decap_3
X_704_ _705_/A _705_/B VGND VGND VPWR VPWR _704_/Y sky130_fd_sc_hd__nor2_2
X_566_ _566_/A _566_/B VGND VGND VPWR VPWR _574_/B sky130_fd_sc_hd__nand2_2
X_635_ _635_/A1 _633_/A _737_/X _385_/Y VGND VGND VPWR VPWR _636_/B sky130_fd_sc_hd__a31o_4
XFILLER_28_93 VGND VGND VPWR VPWR sky130_fd_sc_hd__decap_3
X_497_ _511_/B _497_/B VGND VGND VPWR VPWR _497_/Y sky130_fd_sc_hd__nand2_2
XFILLER_24_29 VGND VGND VPWR VPWR sky130_fd_sc_hd__decap_3
X_420_ _420_/A1 _396_/Y _418_/X _415_/Y VGND VGND VPWR VPWR _420_/Y sky130_fd_sc_hd__a22oi_4
X_549_ _533_/X _537_/Y _547_/Y VGND VGND VPWR VPWR _550_/B sky130_fd_sc_hd__o21a_2
X_618_ _618_/A _618_/B input25/X VGND VGND VPWR VPWR _620_/A sky130_fd_sc_hd__nor3b_2
XFILLER_2_204 VGND VGND VPWR VPWR sky130_fd_sc_hd__decap_3
XFILLER_18_127 VGND VGND VPWR VPWR sky130_fd_sc_hd__fill_1
X_403_ _404_/B _404_/A VGND VGND VPWR VPWR _405_/C sky130_fd_sc_hd__nand2b_2
XFILLER_25_72 VGND VGND VPWR VPWR sky130_fd_sc_hd__decap_3
XFILLER_2_21 VGND VGND VPWR VPWR sky130_fd_sc_hd__decap_3
XFILLER_32_141 VGND VGND VPWR VPWR sky130_fd_sc_hd__decap_3
XFILLER_32_130 VGND VGND VPWR VPWR sky130_fd_sc_hd__decap_3
XFILLER_15_108 VGND VGND VPWR VPWR sky130_fd_sc_hd__decap_3
XFILLER_15_119 VGND VGND VPWR VPWR sky130_fd_sc_hd__decap_3
XFILLER_23_141 VGND VGND VPWR VPWR sky130_fd_sc_hd__decap_3
XTAP_TAPCELL_ROW_33_191 VGND VPWR sky130_fd_sc_hd__tapvpwrvgnd_1
XFILLER_2_3 VGND VGND VPWR VPWR sky130_fd_sc_hd__decap_3
XFILLER_14_141 VGND VGND VPWR VPWR sky130_fd_sc_hd__decap_3
XFILLER_14_174 VGND VGND VPWR VPWR sky130_fd_sc_hd__fill_1
Xinput13 A[20] VGND VGND VPWR VPWR _472_/C sky130_fd_sc_hd__clkdlybuf4s25_1
Xinput24 A[30] VGND VGND VPWR VPWR input24/X sky130_fd_sc_hd__clkdlybuf4s25_1
Xinput35 B[11] VGND VGND VPWR VPWR _705_/B sky130_fd_sc_hd__clkdlybuf4s25_1
Xinput46 B[21] VGND VGND VPWR VPWR _487_/B sky130_fd_sc_hd__clkdlybuf4s25_1
Xinput57 B[31] VGND VGND VPWR VPWR _617_/B sky130_fd_sc_hd__clkdlybuf4s25_1
XFILLER_16_19 VGND VGND VPWR VPWR sky130_fd_sc_hd__fill_2
XFILLER_32_29 VGND VGND VPWR VPWR sky130_fd_sc_hd__fill_2
XFILLER_20_177 VGND VGND VPWR VPWR sky130_fd_sc_hd__decap_3
XFILLER_20_144 VGND VGND VPWR VPWR sky130_fd_sc_hd__decap_3
XFILLER_20_133 VGND VGND VPWR VPWR sky130_fd_sc_hd__decap_3
XFILLER_20_100 VGND VGND VPWR VPWR sky130_fd_sc_hd__decap_3
XFILLER_11_100 VGND VGND VPWR VPWR sky130_fd_sc_hd__decap_3
XFILLER_11_144 VGND VGND VPWR VPWR sky130_fd_sc_hd__decap_3
XFILLER_11_166 VGND VGND VPWR VPWR sky130_fd_sc_hd__fill_2
XFILLER_7_148 VGND VGND VPWR VPWR sky130_fd_sc_hd__decap_3
XFILLER_34_203 VGND VGND VPWR VPWR sky130_fd_sc_hd__decap_3
XFILLER_8_64 VGND VGND VPWR VPWR sky130_fd_sc_hd__decap_3
XTAP_TAPCELL_ROW_10_109 VGND VPWR sky130_fd_sc_hd__tapvpwrvgnd_1
X_720_ _719_/A _719_/B _720_/B1 VGND VGND VPWR VPWR _720_/Y sky130_fd_sc_hd__o21ai_4
X_582_ _583_/A _582_/B _583_/C _583_/D VGND VGND VPWR VPWR _582_/X sky130_fd_sc_hd__and4_2
X_651_ _652_/B _695_/X VGND VGND VPWR VPWR _651_/Y sky130_fd_sc_hd__nand2_2
XFILLER_17_84 VGND VGND VPWR VPWR sky130_fd_sc_hd__decap_3
XTAP_TAPCELL_ROW_4_87 VGND VPWR sky130_fd_sc_hd__tapvpwrvgnd_1
XFILLER_3_184 VGND VGND VPWR VPWR sky130_fd_sc_hd__decap_3
XFILLER_3_151 VGND VGND VPWR VPWR sky130_fd_sc_hd__decap_3
X_634_ _634_/A _634_/B VGND VGND VPWR VPWR _634_/Y sky130_fd_sc_hd__xnor2_2
X_703_ _698_/X _700_/Y _711_/B VGND VGND VPWR VPWR _703_/X sky130_fd_sc_hd__o21a_2
X_565_ _542_/X _558_/X _555_/A VGND VGND VPWR VPWR _566_/B sky130_fd_sc_hd__o21ai_2
X_496_ _490_/Y _486_/X _472_/Y _474_/B _489_/Y VGND VGND VPWR VPWR _523_/A sky130_fd_sc_hd__o2111a_4
XFILLER_5_87 VGND VGND VPWR VPWR sky130_fd_sc_hd__decap_3
XFILLER_5_54 VGND VGND VPWR VPWR sky130_fd_sc_hd__fill_2
XFILLER_14_63 VGND VGND VPWR VPWR sky130_fd_sc_hd__decap_3
XFILLER_14_96 VGND VGND VPWR VPWR sky130_fd_sc_hd__decap_3
XTAP_TAPCELL_ROW_1_77 VGND VPWR sky130_fd_sc_hd__tapvpwrvgnd_1
XFILLER_30_95 VGND VGND VPWR VPWR sky130_fd_sc_hd__decap_3
X_617_ _617_/A _617_/B VGND VGND VPWR VPWR _618_/B sky130_fd_sc_hd__and2_2
X_548_ _564_/A _557_/B _547_/Y _533_/X VGND VGND VPWR VPWR _550_/A sky130_fd_sc_hd__a211oi_2
X_479_ _479_/A _479_/B _479_/C VGND VGND VPWR VPWR _479_/Y sky130_fd_sc_hd__nand3_2
XFILLER_18_139 VGND VGND VPWR VPWR sky130_fd_sc_hd__fill_1
X_402_ _404_/A _404_/B VGND VGND VPWR VPWR _405_/B sky130_fd_sc_hd__nand2b_2
XFILLER_26_183 VGND VGND VPWR VPWR sky130_fd_sc_hd__decap_3
XFILLER_26_161 VGND VGND VPWR VPWR sky130_fd_sc_hd__decap_3
XFILLER_25_84 VGND VGND VPWR VPWR sky130_fd_sc_hd__decap_3
XFILLER_25_51 VGND VGND VPWR VPWR sky130_fd_sc_hd__decap_3
XFILLER_2_66 VGND VGND VPWR VPWR sky130_fd_sc_hd__decap_3
XFILLER_17_172 VGND VGND VPWR VPWR sky130_fd_sc_hd__decap_3
XFILLER_32_197 VGND VGND VPWR VPWR sky130_fd_sc_hd__decap_3
XFILLER_32_186 VGND VGND VPWR VPWR sky130_fd_sc_hd__decap_3
XFILLER_23_164 VGND VGND VPWR VPWR sky130_fd_sc_hd__decap_3
XFILLER_11_53 VGND VGND VPWR VPWR sky130_fd_sc_hd__decap_3
XFILLER_11_64 VGND VGND VPWR VPWR sky130_fd_sc_hd__decap_3
XFILLER_11_97 VGND VGND VPWR VPWR sky130_fd_sc_hd__decap_3
XFILLER_14_120 VGND VGND VPWR VPWR sky130_fd_sc_hd__decap_3
XFILLER_14_197 VGND VGND VPWR VPWR sky130_fd_sc_hd__decap_3
Xinput14 A[21] VGND VGND VPWR VPWR _490_/B1 sky130_fd_sc_hd__clkdlybuf4s25_1
Xinput25 A[31] VGND VGND VPWR VPWR input25/X sky130_fd_sc_hd__clkdlybuf4s25_1
Xinput36 B[12] VGND VGND VPWR VPWR _682_/B sky130_fd_sc_hd__clkdlybuf4s25_1
XTAP_TAPCELL_ROW_7_98 VGND VPWR sky130_fd_sc_hd__tapvpwrvgnd_1
Xinput47 B[22] VGND VGND VPWR VPWR _502_/B sky130_fd_sc_hd__clkdlybuf4s25_1
Xinput58 B[3] VGND VGND VPWR VPWR _395_/B sky130_fd_sc_hd__clkdlybuf4s25_1
XFILLER_20_112 VGND VGND VPWR VPWR sky130_fd_sc_hd__decap_3
XFILLER_20_156 VGND VGND VPWR VPWR sky130_fd_sc_hd__decap_3
XFILLER_7_127 VGND VGND VPWR VPWR sky130_fd_sc_hd__decap_3
XFILLER_22_85 VGND VGND VPWR VPWR sky130_fd_sc_hd__decap_3
XFILLER_6_160 VGND VGND VPWR VPWR sky130_fd_sc_hd__decap_3
X_650_ _710_/Y _650_/B VGND VGND VPWR VPWR _650_/X sky130_fd_sc_hd__xor2_2
X_581_ _581_/A VGND VGND VPWR VPWR _607_/A sky130_fd_sc_hd__inv_2
XFILLER_17_63 VGND VGND VPWR VPWR sky130_fd_sc_hd__decap_3
XFILLER_17_52 VGND VGND VPWR VPWR sky130_fd_sc_hd__decap_3
XTAP_TAPCELL_ROW_4_88 VGND VPWR sky130_fd_sc_hd__tapvpwrvgnd_1
XFILLER_33_84 VGND VGND VPWR VPWR sky130_fd_sc_hd__decap_3
XFILLER_3_163 VGND VGND VPWR VPWR sky130_fd_sc_hd__decap_3
XFILLER_12_6 VGND VGND VPWR VPWR sky130_fd_sc_hd__fill_2
X_633_ _633_/A _633_/B VGND VGND VPWR VPWR _634_/B sky130_fd_sc_hd__nand2_4
X_702_ _699_/Y _698_/X input2/X VGND VGND VPWR VPWR _711_/B sky130_fd_sc_hd__o21bai_4
XFILLER_28_73 VGND VGND VPWR VPWR sky130_fd_sc_hd__decap_3
X_564_ _564_/A _583_/A _582_/B VGND VGND VPWR VPWR _574_/A sky130_fd_sc_hd__nand3_4
X_495_ _495_/A _495_/B VGND VGND VPWR VPWR _495_/Y sky130_fd_sc_hd__nand2_4
XFILLER_10_3 VGND VGND VPWR VPWR sky130_fd_sc_hd__fill_2
XFILLER_14_53 VGND VGND VPWR VPWR sky130_fd_sc_hd__decap_3
XFILLER_14_75 VGND VGND VPWR VPWR sky130_fd_sc_hd__decap_3
XFILLER_30_52 VGND VGND VPWR VPWR sky130_fd_sc_hd__decap_3
XTAP_TAPCELL_ROW_1_78 VGND VPWR sky130_fd_sc_hd__tapvpwrvgnd_1
X_547_ _547_/A VGND VGND VPWR VPWR _547_/Y sky130_fd_sc_hd__inv_2
X_616_ _617_/A _617_/B VGND VGND VPWR VPWR _618_/A sky130_fd_sc_hd__nor2_2
X_478_ _480_/A _456_/X _476_/C _479_/B VGND VGND VPWR VPWR _478_/X sky130_fd_sc_hd__o211a_2
X_401_ _399_/A _399_/B _631_/A1 VGND VGND VPWR VPWR _401_/Y sky130_fd_sc_hd__o21ai_2
XFILLER_25_30 VGND VGND VPWR VPWR sky130_fd_sc_hd__decap_3
XFILLER_25_96 VGND VGND VPWR VPWR sky130_fd_sc_hd__decap_3
XFILLER_25_63 VGND VGND VPWR VPWR sky130_fd_sc_hd__decap_3
XFILLER_32_154 VGND VGND VPWR VPWR sky130_fd_sc_hd__decap_3
XFILLER_23_132 VGND VGND VPWR VPWR sky130_fd_sc_hd__decap_3
XTAP_TAPCELL_ROW_7_99 VGND VPWR sky130_fd_sc_hd__tapvpwrvgnd_1
Xinput15 A[22] VGND VGND VPWR VPWR input15/X sky130_fd_sc_hd__clkdlybuf4s25_1
Xinput26 A[3] VGND VGND VPWR VPWR _420_/A1 sky130_fd_sc_hd__clkdlybuf4s25_1
Xinput37 B[13] VGND VGND VPWR VPWR _680_/B sky130_fd_sc_hd__clkdlybuf4s25_1
Xinput48 B[23] VGND VGND VPWR VPWR _514_/B sky130_fd_sc_hd__clkdlybuf4s25_1
Xinput59 B[4] VGND VGND VPWR VPWR _734_/B sky130_fd_sc_hd__clkdlybuf4s25_1
XTAP_TAPCELL_ROW_24_160 VGND VPWR sky130_fd_sc_hd__tapvpwrvgnd_1
XFILLER_20_124 VGND VGND VPWR VPWR sky130_fd_sc_hd__decap_3
XFILLER_20_168 VGND VGND VPWR VPWR sky130_fd_sc_hd__decap_3
XFILLER_11_113 VGND VGND VPWR VPWR sky130_fd_sc_hd__fill_1
XTAP_TAPCELL_ROW_13_119 VGND VPWR sky130_fd_sc_hd__tapvpwrvgnd_1
XFILLER_22_75 VGND VGND VPWR VPWR sky130_fd_sc_hd__decap_3
XFILLER_22_97 VGND VGND VPWR VPWR sky130_fd_sc_hd__decap_3
X_580_ _580_/A _598_/A VGND VGND VPWR VPWR _581_/A sky130_fd_sc_hd__nand2_2
XFILLER_16_205 VGND VGND VPWR VPWR sky130_fd_sc_hd__decap_3
XPHY_EDGE_ROW_9_Left_44 VGND VGND VPWR VPWR sky130_fd_sc_hd__decap_3
XFILLER_17_75 VGND VGND VPWR VPWR sky130_fd_sc_hd__decap_3
XTAP_TAPCELL_ROW_4_89 VGND VPWR sky130_fd_sc_hd__tapvpwrvgnd_1
XPHY_EDGE_ROW_17_Right_17 VGND VGND VPWR VPWR sky130_fd_sc_hd__decap_3
XPHY_EDGE_ROW_26_Right_26 VGND VGND VPWR VPWR sky130_fd_sc_hd__decap_3
XFILLER_0_189 VGND VGND VPWR VPWR sky130_fd_sc_hd__decap_3
X_563_ _563_/A _563_/B VGND VGND VPWR VPWR _563_/Y sky130_fd_sc_hd__nand2_2
X_632_ _632_/A _632_/B VGND VGND VPWR VPWR _632_/Y sky130_fd_sc_hd__xnor2_2
X_701_ _719_/A _699_/B _700_/Y VGND VGND VPWR VPWR _711_/C sky130_fd_sc_hd__a21o_4
XFILLER_28_96 VGND VGND VPWR VPWR sky130_fd_sc_hd__decap_3
XFILLER_28_52 VGND VGND VPWR VPWR sky130_fd_sc_hd__decap_3
X_494_ _474_/A _485_/A _488_/X _491_/Y VGND VGND VPWR VPWR _495_/B sky130_fd_sc_hd__o2bb2ai_4
XTAP_TAPCELL_ROW_1_79 VGND VPWR sky130_fd_sc_hd__tapvpwrvgnd_1
X_546_ _557_/A _558_/B VGND VGND VPWR VPWR _547_/A sky130_fd_sc_hd__nand2_2
X_615_ _615_/A _615_/B VGND VGND VPWR VPWR _615_/Y sky130_fd_sc_hd__nand2_2
XFILLER_29_160 VGND VGND VPWR VPWR sky130_fd_sc_hd__decap_3
X_477_ _454_/B _477_/B _669_/A _669_/B VGND VGND VPWR VPWR _585_/C sky130_fd_sc_hd__nand4b_4
XFILLER_2_207 VGND VGND VPWR VPWR sky130_fd_sc_hd__fill_1
X_400_ _400_/A _400_/B VGND VGND VPWR VPWR _400_/Y sky130_fd_sc_hd__nor2_2
XFILLER_26_141 VGND VGND VPWR VPWR sky130_fd_sc_hd__decap_3
XFILLER_25_42 VGND VGND VPWR VPWR sky130_fd_sc_hd__decap_3
XFILLER_25_75 VGND VGND VPWR VPWR sky130_fd_sc_hd__decap_3
XPHY_EDGE_ROW_22_Left_57 VGND VGND VPWR VPWR sky130_fd_sc_hd__decap_3
XFILLER_2_46 VGND VGND VPWR VPWR sky130_fd_sc_hd__fill_1
XFILLER_2_24 VGND VGND VPWR VPWR sky130_fd_sc_hd__decap_3
X_529_ _529_/A _529_/B VGND VGND VPWR VPWR _564_/A sky130_fd_sc_hd__nand2_4
XFILLER_32_177 VGND VGND VPWR VPWR sky130_fd_sc_hd__decap_3
XFILLER_32_144 VGND VGND VPWR VPWR sky130_fd_sc_hd__fill_1
XFILLER_32_133 VGND VGND VPWR VPWR sky130_fd_sc_hd__decap_3
XFILLER_23_188 VGND VGND VPWR VPWR sky130_fd_sc_hd__decap_3
XFILLER_2_6 VGND VGND VPWR VPWR sky130_fd_sc_hd__decap_3
XFILLER_14_111 VGND VGND VPWR VPWR sky130_fd_sc_hd__decap_3
XFILLER_14_144 VGND VGND VPWR VPWR sky130_fd_sc_hd__decap_3
Xinput16 A[23] VGND VGND VPWR VPWR _519_/A sky130_fd_sc_hd__clkdlybuf4s25_1
Xinput27 A[4] VGND VGND VPWR VPWR _736_/B1 sky130_fd_sc_hd__clkdlybuf4s25_1
Xinput38 B[14] VGND VGND VPWR VPWR _675_/A sky130_fd_sc_hd__clkdlybuf4s25_1
Xinput49 B[24] VGND VGND VPWR VPWR _532_/B sky130_fd_sc_hd__clkdlybuf4s25_1
XFILLER_20_147 VGND VGND VPWR VPWR sky130_fd_sc_hd__decap_3
XFILLER_20_136 VGND VGND VPWR VPWR sky130_fd_sc_hd__decap_3
XFILLER_20_103 VGND VGND VPWR VPWR sky130_fd_sc_hd__decap_3
XFILLER_11_103 VGND VGND VPWR VPWR sky130_fd_sc_hd__decap_3
XFILLER_11_147 VGND VGND VPWR VPWR sky130_fd_sc_hd__decap_3
XFILLER_7_118 VGND VGND VPWR VPWR sky130_fd_sc_hd__decap_3
XFILLER_22_43 VGND VGND VPWR VPWR sky130_fd_sc_hd__decap_3
XFILLER_0_3 VGND VGND VPWR VPWR sky130_fd_sc_hd__decap_3
XFILLER_34_206 VGND VGND VPWR VPWR sky130_fd_sc_hd__fill_2
XFILLER_8_67 VGND VGND VPWR VPWR sky130_fd_sc_hd__fill_2
XPHY_EDGE_ROW_25_Left_60 VGND VGND VPWR VPWR sky130_fd_sc_hd__decap_3
XFILLER_33_3 VGND VGND VPWR VPWR sky130_fd_sc_hd__fill_1
XFILLER_17_87 VGND VGND VPWR VPWR sky130_fd_sc_hd__decap_3
XFILLER_3_154 VGND VGND VPWR VPWR sky130_fd_sc_hd__decap_3
XFILLER_3_143 VGND VGND VPWR VPWR sky130_fd_sc_hd__fill_1
XFILLER_3_187 VGND VGND VPWR VPWR sky130_fd_sc_hd__decap_3
XFILLER_0_102 VGND VGND VPWR VPWR sky130_fd_sc_hd__fill_2
XFILLER_0_113 VGND VGND VPWR VPWR sky130_fd_sc_hd__decap_3
X_700_ _719_/A _699_/B input2/X VGND VGND VPWR VPWR _700_/Y sky130_fd_sc_hd__o21ai_2
X_562_ _562_/A _562_/B VGND VGND VPWR VPWR _563_/B sky130_fd_sc_hd__nand2_2
X_631_ _631_/A1 _400_/Y _415_/Y _430_/C VGND VGND VPWR VPWR _632_/B sky130_fd_sc_hd__o22a_2
X_493_ _486_/X _490_/Y _524_/A1 _474_/A _485_/A VGND VGND VPWR VPWR _495_/A sky130_fd_sc_hd__o2111ai_2
XFILLER_14_66 VGND VGND VPWR VPWR sky130_fd_sc_hd__decap_3
XFILLER_14_99 VGND VGND VPWR VPWR sky130_fd_sc_hd__decap_3
XFILLER_29_172 VGND VGND VPWR VPWR sky130_fd_sc_hd__decap_3
X_545_ _671_/B _541_/B _544_/Y VGND VGND VPWR VPWR _558_/B sky130_fd_sc_hd__o21ai_2
X_614_ _611_/Y _613_/Y _612_/Y VGND VGND VPWR VPWR _614_/Y sky130_fd_sc_hd__o21ai_4
X_476_ _476_/A _476_/B _476_/C _479_/B VGND VGND VPWR VPWR _477_/B sky130_fd_sc_hd__and4_2
XFILLER_29_194 VGND VGND VPWR VPWR sky130_fd_sc_hd__decap_3
XFILLER_18_109 VGND VGND VPWR VPWR sky130_fd_sc_hd__decap_3
XFILLER_26_186 VGND VGND VPWR VPWR sky130_fd_sc_hd__decap_3
XFILLER_26_164 VGND VGND VPWR VPWR sky130_fd_sc_hd__fill_2
XFILLER_25_87 VGND VGND VPWR VPWR sky130_fd_sc_hd__decap_3
XFILLER_25_54 VGND VGND VPWR VPWR sky130_fd_sc_hd__fill_2
XFILLER_25_21 VGND VGND VPWR VPWR sky130_fd_sc_hd__decap_3
Xrebuffer140 _734_/A VGND VGND VPWR VPWR _670_/A sky130_fd_sc_hd__buf_2
XFILLER_2_69 VGND VGND VPWR VPWR sky130_fd_sc_hd__fill_1
X_528_ _436_/Y _432_/Y _527_/Y _435_/X VGND VGND VPWR VPWR _529_/B sky130_fd_sc_hd__o211ai_4
X_459_ _486_/A _461_/B VGND VGND VPWR VPWR _459_/Y sky130_fd_sc_hd__nor2_2
XTAP_TAPCELL_ROW_27_170 VGND VPWR sky130_fd_sc_hd__tapvpwrvgnd_1
XFILLER_32_189 VGND VGND VPWR VPWR sky130_fd_sc_hd__decap_3
XFILLER_17_175 VGND VGND VPWR VPWR sky130_fd_sc_hd__fill_1
XFILLER_23_167 VGND VGND VPWR VPWR sky130_fd_sc_hd__fill_1
XFILLER_11_67 VGND VGND VPWR VPWR sky130_fd_sc_hd__decap_3
XFILLER_14_123 VGND VGND VPWR VPWR sky130_fd_sc_hd__decap_3
XTAP_TAPCELL_ROW_16_129 VGND VPWR sky130_fd_sc_hd__tapvpwrvgnd_1
Xinput17 A[24] VGND VGND VPWR VPWR _534_/C sky130_fd_sc_hd__clkdlybuf4s25_1
Xinput28 A[5] VGND VGND VPWR VPWR _358_/B1 sky130_fd_sc_hd__clkdlybuf4s25_1
Xinput39 B[15] VGND VGND VPWR VPWR _670_/B sky130_fd_sc_hd__clkdlybuf4s25_1
XFILLER_20_159 VGND VGND VPWR VPWR sky130_fd_sc_hd__decap_3
XFILLER_20_115 VGND VGND VPWR VPWR sky130_fd_sc_hd__decap_3
XFILLER_22_88 VGND VGND VPWR VPWR sky130_fd_sc_hd__decap_3
XFILLER_22_33 VGND VGND VPWR VPWR sky130_fd_sc_hd__decap_3
XFILLER_6_163 VGND VGND VPWR VPWR sky130_fd_sc_hd__decap_3
XFILLER_6_141 VGND VGND VPWR VPWR sky130_fd_sc_hd__fill_2
XFILLER_26_3 VGND VGND VPWR VPWR sky130_fd_sc_hd__decap_3
XFILLER_17_66 VGND VGND VPWR VPWR sky130_fd_sc_hd__decap_3
XFILLER_17_55 VGND VGND VPWR VPWR sky130_fd_sc_hd__fill_1
XFILLER_33_87 VGND VGND VPWR VPWR sky130_fd_sc_hd__fill_1
XFILLER_3_166 VGND VGND VPWR VPWR sky130_fd_sc_hd__fill_2
XPHY_EDGE_ROW_3_Right_3 VGND VGND VPWR VPWR sky130_fd_sc_hd__decap_3
XFILLER_0_136 VGND VGND VPWR VPWR sky130_fd_sc_hd__decap_3
XFILLER_0_169 VGND VGND VPWR VPWR sky130_fd_sc_hd__fill_2
X_630_ _630_/A _630_/B VGND VGND VPWR VPWR _630_/X sky130_fd_sc_hd__xor2_2
XFILLER_28_32 VGND VGND VPWR VPWR sky130_fd_sc_hd__fill_2
X_561_ _564_/A _561_/A2 _559_/Y _562_/A VGND VGND VPWR VPWR _563_/A sky130_fd_sc_hd__a211o_2
X_492_ _486_/X _490_/Y _524_/A1 VGND VGND VPWR VPWR _510_/B sky130_fd_sc_hd__o21a_2
XFILLER_28_76 VGND VGND VPWR VPWR sky130_fd_sc_hd__decap_3
XFILLER_14_56 VGND VGND VPWR VPWR sky130_fd_sc_hd__decap_3
XFILLER_14_78 VGND VGND VPWR VPWR sky130_fd_sc_hd__decap_3
XFILLER_30_55 VGND VGND VPWR VPWR sky130_fd_sc_hd__decap_3
X_613_ _623_/A _615_/A VGND VGND VPWR VPWR _613_/Y sky130_fd_sc_hd__nand2_2
XFILLER_29_151 VGND VGND VPWR VPWR sky130_fd_sc_hd__decap_3
X_544_ _671_/B _541_/B input18/X VGND VGND VPWR VPWR _544_/Y sky130_fd_sc_hd__a21boi_2
X_475_ _475_/A VGND VGND VPWR VPWR _510_/A sky130_fd_sc_hd__inv_2
XFILLER_26_121 VGND VGND VPWR VPWR sky130_fd_sc_hd__decap_3
XFILLER_25_99 VGND VGND VPWR VPWR sky130_fd_sc_hd__decap_3
XFILLER_25_66 VGND VGND VPWR VPWR sky130_fd_sc_hd__decap_3
XFILLER_25_33 VGND VGND VPWR VPWR sky130_fd_sc_hd__fill_1
Xrebuffer141 _734_/A VGND VGND VPWR VPWR _385_/A1 sky130_fd_sc_hd__buf_2
Xrebuffer130 _585_/C VGND VGND VPWR VPWR _482_/B2 sky130_fd_sc_hd__buf_2
X_527_ _585_/B _585_/C VGND VGND VPWR VPWR _527_/Y sky130_fd_sc_hd__nor2_4
XFILLER_17_165 VGND VGND VPWR VPWR sky130_fd_sc_hd__decap_3
XFILLER_17_110 VGND VGND VPWR VPWR sky130_fd_sc_hd__fill_2
X_458_ _458_/A _458_/B VGND VGND VPWR VPWR _458_/X sky130_fd_sc_hd__xor2_2
X_389_ _634_/A _640_/A VGND VGND VPWR VPWR _392_/D sky130_fd_sc_hd__nor2_2
XFILLER_32_157 VGND VGND VPWR VPWR sky130_fd_sc_hd__fill_1
XFILLER_32_124 VGND VGND VPWR VPWR sky130_fd_sc_hd__fill_1
XTAP_TAPCELL_ROW_2_80 VGND VPWR sky130_fd_sc_hd__tapvpwrvgnd_1
XFILLER_23_135 VGND VGND VPWR VPWR sky130_fd_sc_hd__decap_3
XFILLER_23_102 VGND VGND VPWR VPWR sky130_fd_sc_hd__fill_1
XFILLER_14_102 VGND VGND VPWR VPWR sky130_fd_sc_hd__decap_3
Xinput18 A[25] VGND VGND VPWR VPWR input18/X sky130_fd_sc_hd__clkdlybuf4s25_1
Xinput29 A[6] VGND VGND VPWR VPWR _369_/B1 sky130_fd_sc_hd__clkdlybuf4s25_1
XFILLER_20_127 VGND VGND VPWR VPWR sky130_fd_sc_hd__decap_3
XFILLER_22_78 VGND VGND VPWR VPWR sky130_fd_sc_hd__decap_3
XFILLER_6_197 VGND VGND VPWR VPWR sky130_fd_sc_hd__decap_3
XFILLER_6_175 VGND VGND VPWR VPWR sky130_fd_sc_hd__fill_1
XFILLER_17_78 VGND VGND VPWR VPWR sky130_fd_sc_hd__decap_3
X_560_ _561_/A2 _560_/A2_N _542_/X _558_/X VGND VGND VPWR VPWR _562_/B sky130_fd_sc_hd__o2bb2ai_2
XFILLER_28_99 VGND VGND VPWR VPWR sky130_fd_sc_hd__decap_3
XFILLER_28_55 VGND VGND VPWR VPWR sky130_fd_sc_hd__decap_3
X_491_ _491_/A1 _487_/B _490_/Y VGND VGND VPWR VPWR _491_/Y sky130_fd_sc_hd__a21oi_2
X_689_ _697_/A _689_/B _689_/C VGND VGND VPWR VPWR _690_/B sky130_fd_sc_hd__nand3_2
XPHY_EDGE_ROW_13_Right_13 VGND VGND VPWR VPWR sky130_fd_sc_hd__decap_3
XTAP_TAPCELL_ROW_5_91 VGND VPWR sky130_fd_sc_hd__tapvpwrvgnd_1
XPHY_EDGE_ROW_22_Right_22 VGND VGND VPWR VPWR sky130_fd_sc_hd__decap_3
XPHY_EDGE_ROW_31_Right_31 VGND VGND VPWR VPWR sky130_fd_sc_hd__decap_3
X_543_ _540_/Y _541_/X input18/X VGND VGND VPWR VPWR _557_/A sky130_fd_sc_hd__o21bai_2
X_612_ _606_/A _624_/A _615_/B _611_/Y VGND VGND VPWR VPWR _612_/Y sky130_fd_sc_hd__o22ai_2
XFILLER_29_163 VGND VGND VPWR VPWR sky130_fd_sc_hd__decap_3
X_474_ _474_/A _474_/B VGND VGND VPWR VPWR _475_/A sky130_fd_sc_hd__nand2_2
XFILLER_6_80 VGND VGND VPWR VPWR sky130_fd_sc_hd__decap_3
XFILLER_26_144 VGND VGND VPWR VPWR sky130_fd_sc_hd__fill_2
XFILLER_26_100 VGND VGND VPWR VPWR sky130_fd_sc_hd__decap_3
XFILLER_25_78 VGND VGND VPWR VPWR sky130_fd_sc_hd__decap_3
XFILLER_25_45 VGND VGND VPWR VPWR sky130_fd_sc_hd__decap_3
Xrebuffer142 _705_/A VGND VGND VPWR VPWR _617_/A sky130_fd_sc_hd__buf_2
Xrebuffer131 _472_/Y VGND VGND VPWR VPWR _474_/A sky130_fd_sc_hd__buf_2
Xrebuffer120 _711_/D VGND VGND VPWR VPWR _382_/C1 sky130_fd_sc_hd__buf_2
XFILLER_2_27 VGND VGND VPWR VPWR sky130_fd_sc_hd__fill_1
X_526_ _518_/Y _524_/Y _585_/B _481_/Y VGND VGND VPWR VPWR _526_/Y sky130_fd_sc_hd__o22ai_2
XFILLER_32_136 VGND VGND VPWR VPWR sky130_fd_sc_hd__decap_3
X_457_ _454_/X _457_/A2 _456_/X VGND VGND VPWR VPWR _458_/B sky130_fd_sc_hd__o21a_2
X_388_ _730_/X _375_/Y _731_/Y VGND VGND VPWR VPWR _640_/A sky130_fd_sc_hd__o21ai_2
XTAP_TAPCELL_ROW_2_81 VGND VPWR sky130_fd_sc_hd__tapvpwrvgnd_1
XFILLER_23_169 VGND VGND VPWR VPWR sky130_fd_sc_hd__fill_1
XFILLER_2_9 VGND VGND VPWR VPWR sky130_fd_sc_hd__fill_1
XFILLER_14_114 VGND VGND VPWR VPWR sky130_fd_sc_hd__decap_3
XFILLER_14_136 VGND VGND VPWR VPWR sky130_fd_sc_hd__decap_3
XFILLER_14_147 VGND VGND VPWR VPWR sky130_fd_sc_hd__decap_3
Xinput19 A[26] VGND VGND VPWR VPWR _664_/A sky130_fd_sc_hd__clkdlybuf4s25_1
X_509_ _509_/A _509_/B VGND VGND VPWR VPWR _509_/Y sky130_fd_sc_hd__nand2_2
XFILLER_20_139 VGND VGND VPWR VPWR sky130_fd_sc_hd__fill_1
XFILLER_20_106 VGND VGND VPWR VPWR sky130_fd_sc_hd__decap_3
XTAP_TAPCELL_ROW_30_178 VGND VPWR sky130_fd_sc_hd__tapvpwrvgnd_1
XFILLER_9_140 VGND VGND VPWR VPWR sky130_fd_sc_hd__decap_3
XFILLER_11_106 VGND VGND VPWR VPWR sky130_fd_sc_hd__decap_3
XFILLER_22_46 VGND VGND VPWR VPWR sky130_fd_sc_hd__decap_3
XFILLER_0_6 VGND VGND VPWR VPWR sky130_fd_sc_hd__decap_3
XFILLER_19_206 VGND VGND VPWR VPWR sky130_fd_sc_hd__fill_2
XFILLER_10_150 VGND VGND VPWR VPWR sky130_fd_sc_hd__fill_2
XFILLER_8_26 VGND VGND VPWR VPWR sky130_fd_sc_hd__fill_2
XFILLER_17_57 VGND VGND VPWR VPWR sky130_fd_sc_hd__decap_3
XFILLER_3_157 VGND VGND VPWR VPWR sky130_fd_sc_hd__decap_3
XFILLER_3_113 VGND VGND VPWR VPWR sky130_fd_sc_hd__decap_3
XPHY_EDGE_ROW_29_Left_64 VGND VGND VPWR VPWR sky130_fd_sc_hd__decap_3
XPHY_EDGE_ROW_13_Left_48 VGND VGND VPWR VPWR sky130_fd_sc_hd__decap_3
XFILLER_9_91 VGND VGND VPWR VPWR sky130_fd_sc_hd__decap_3
XFILLER_0_116 VGND VGND VPWR VPWR sky130_fd_sc_hd__decap_3
X_490_ _530_/A _487_/B _490_/B1 VGND VGND VPWR VPWR _490_/Y sky130_fd_sc_hd__o21ai_2
XFILLER_5_38 VGND VGND VPWR VPWR sky130_fd_sc_hd__fill_1
X_688_ _674_/X _676_/Y _687_/Y _681_/Y VGND VGND VPWR VPWR _689_/C sky130_fd_sc_hd__o211ai_2
XTAP_TAPCELL_ROW_5_92 VGND VPWR sky130_fd_sc_hd__tapvpwrvgnd_1
XFILLER_14_25 VGND VGND VPWR VPWR sky130_fd_sc_hd__decap_3
XFILLER_14_69 VGND VGND VPWR VPWR sky130_fd_sc_hd__decap_3
XFILLER_30_46 VGND VGND VPWR VPWR sky130_fd_sc_hd__decap_3
X_542_ _540_/Y _541_/X input18/X VGND VGND VPWR VPWR _542_/X sky130_fd_sc_hd__o21ba_2
X_611_ _611_/A VGND VGND VPWR VPWR _611_/Y sky130_fd_sc_hd__inv_2
X_473_ _469_/Y _470_/X _472_/C VGND VGND VPWR VPWR _474_/B sky130_fd_sc_hd__o21bai_4
XFILLER_29_197 VGND VGND VPWR VPWR sky130_fd_sc_hd__decap_3
XFILLER_29_186 VGND VGND VPWR VPWR sky130_fd_sc_hd__decap_3
XFILLER_29_175 VGND VGND VPWR VPWR sky130_fd_sc_hd__decap_3
XFILLER_29_142 VGND VGND VPWR VPWR sky130_fd_sc_hd__decap_3
XPHY_EDGE_ROW_16_Left_51 VGND VGND VPWR VPWR sky130_fd_sc_hd__decap_3
XFILLER_26_112 VGND VGND VPWR VPWR sky130_fd_sc_hd__decap_3
XFILLER_25_24 VGND VGND VPWR VPWR sky130_fd_sc_hd__decap_3
Xrebuffer132 _489_/Y VGND VGND VPWR VPWR _524_/A1 sky130_fd_sc_hd__buf_2
Xrebuffer121 fanout115/X VGND VGND VPWR VPWR _735_/B sky130_fd_sc_hd__buf_2
XFILLER_25_57 VGND VGND VPWR VPWR sky130_fd_sc_hd__decap_3
Xrebuffer187 _425_/A VGND VGND VPWR VPWR _629_/A2 sky130_fd_sc_hd__buf_2
Xrebuffer143 _722_/X VGND VGND VPWR VPWR _643_/C sky130_fd_sc_hd__buf_2
X_525_ _521_/B _518_/Y _585_/B _481_/Y _523_/C VGND VGND VPWR VPWR _529_/A sky130_fd_sc_hd__o221a_4
X_456_ _669_/A _479_/A _455_/A VGND VGND VPWR VPWR _456_/X sky130_fd_sc_hd__a21bo_2
X_387_ _732_/X _736_/Y _733_/X _384_/Y VGND VGND VPWR VPWR _634_/A sky130_fd_sc_hd__o22ai_2
XFILLER_15_90 VGND VGND VPWR VPWR sky130_fd_sc_hd__decap_3
XTAP_TAPCELL_ROW_2_82 VGND VPWR sky130_fd_sc_hd__tapvpwrvgnd_1
XFILLER_31_181 VGND VGND VPWR VPWR sky130_fd_sc_hd__decap_3
XFILLER_23_126 VGND VGND VPWR VPWR sky130_fd_sc_hd__decap_3
XFILLER_14_126 VGND VGND VPWR VPWR sky130_fd_sc_hd__decap_3
XPHY_EDGE_ROW_1_Left_36 VGND VGND VPWR VPWR sky130_fd_sc_hd__decap_3
X_508_ _508_/A _508_/B VGND VGND VPWR VPWR _509_/B sky130_fd_sc_hd__nand2_2
X_439_ _439_/A _440_/B VGND VGND VPWR VPWR _441_/A sky130_fd_sc_hd__or2_4
XFILLER_20_118 VGND VGND VPWR VPWR sky130_fd_sc_hd__decap_3
XTAP_TAPCELL_ROW_30_179 VGND VPWR sky130_fd_sc_hd__tapvpwrvgnd_1
XFILLER_3_71 VGND VGND VPWR VPWR sky130_fd_sc_hd__decap_3
XFILLER_22_25 VGND VGND VPWR VPWR sky130_fd_sc_hd__decap_3
XFILLER_6_166 VGND VGND VPWR VPWR sky130_fd_sc_hd__decap_3
XFILLER_26_6 VGND VGND VPWR VPWR sky130_fd_sc_hd__decap_3
XFILLER_33_57 VGND VGND VPWR VPWR sky130_fd_sc_hd__decap_3
XFILLER_17_69 VGND VGND VPWR VPWR sky130_fd_sc_hd__decap_3
XFILLER_23_90 VGND VGND VPWR VPWR sky130_fd_sc_hd__decap_3
XFILLER_24_3 VGND VGND VPWR VPWR sky130_fd_sc_hd__fill_1
XFILLER_9_81 VGND VGND VPWR VPWR sky130_fd_sc_hd__fill_2
XFILLER_0_139 VGND VGND VPWR VPWR sky130_fd_sc_hd__fill_1
XPHY_EDGE_ROW_30_Left_65 VGND VGND VPWR VPWR sky130_fd_sc_hd__decap_3
X_687_ _682_/Y _684_/X _686_/Y _679_/X VGND VGND VPWR VPWR _687_/Y sky130_fd_sc_hd__o2bb2ai_4
XTAP_TAPCELL_ROW_5_93 VGND VPWR sky130_fd_sc_hd__tapvpwrvgnd_1
XPHY_EDGE_ROW_7_Right_7 VGND VGND VPWR VPWR sky130_fd_sc_hd__decap_3
XFILLER_30_58 VGND VGND VPWR VPWR sky130_fd_sc_hd__decap_3
XFILLER_30_36 VGND VGND VPWR VPWR sky130_fd_sc_hd__decap_3
X_610_ _596_/X _598_/A _607_/B VGND VGND VPWR VPWR _611_/A sky130_fd_sc_hd__o21a_2
XFILLER_29_154 VGND VGND VPWR VPWR sky130_fd_sc_hd__decap_3
X_541_ _602_/A _541_/B VGND VGND VPWR VPWR _541_/X sky130_fd_sc_hd__and2_2
X_472_ _469_/Y _472_/B _472_/C VGND VGND VPWR VPWR _472_/Y sky130_fd_sc_hd__nand3b_4
XFILLER_20_91 VGND VGND VPWR VPWR sky130_fd_sc_hd__decap_3
XFILLER_20_80 VGND VGND VPWR VPWR sky130_fd_sc_hd__decap_3
XFILLER_26_124 VGND VGND VPWR VPWR sky130_fd_sc_hd__decap_3
XFILLER_25_69 VGND VGND VPWR VPWR sky130_fd_sc_hd__decap_3
Xrebuffer144 _583_/B VGND VGND VPWR VPWR _561_/A2 sky130_fd_sc_hd__buf_2
Xrebuffer133 _486_/A VGND VGND VPWR VPWR _471_/A sky130_fd_sc_hd__buf_2
Xrebuffer122 _379_/A VGND VGND VPWR VPWR _641_/A2 sky130_fd_sc_hd__buf_2
Xrebuffer166 _437_/Y VGND VGND VPWR VPWR _457_/A2 sky130_fd_sc_hd__buf_2
XFILLER_2_29 VGND VGND VPWR VPWR sky130_fd_sc_hd__fill_2
XFILLER_2_18 VGND VGND VPWR VPWR sky130_fd_sc_hd__decap_3
XFILLER_17_113 VGND VGND VPWR VPWR sky130_fd_sc_hd__decap_3
X_524_ _524_/A1 _499_/Y _505_/B _516_/X _503_/Y VGND VGND VPWR VPWR _524_/Y sky130_fd_sc_hd__a311oi_2
X_455_ _455_/A _668_/B _668_/A VGND VGND VPWR VPWR _479_/C sky130_fd_sc_hd__nand3_2
X_386_ _736_/B1 _734_/Y _735_/Y VGND VGND VPWR VPWR _390_/D sky130_fd_sc_hd__nand3b_2
Xoutput90 _625_/Y VGND VGND VPWR VPWR S[31] sky130_fd_sc_hd__buf_6
XTAP_TAPCELL_ROW_2_83 VGND VPWR sky130_fd_sc_hd__tapvpwrvgnd_1
XFILLER_23_138 VGND VGND VPWR VPWR sky130_fd_sc_hd__decap_3
XFILLER_14_105 VGND VGND VPWR VPWR sky130_fd_sc_hd__decap_3
X_507_ _488_/X _498_/X _523_/B _497_/Y VGND VGND VPWR VPWR _509_/A sky130_fd_sc_hd__o211ai_2
X_438_ _669_/Y _438_/B VGND VGND VPWR VPWR _438_/X sky130_fd_sc_hd__xor2_2
X_369_ _369_/A1 _366_/B _369_/B1 VGND VGND VPWR VPWR _369_/Y sky130_fd_sc_hd__o21ai_2
XFILLER_9_131 VGND VGND VPWR VPWR sky130_fd_sc_hd__decap_3
XTAP_TAPCELL_ROW_21_147 VGND VPWR sky130_fd_sc_hd__tapvpwrvgnd_1
XFILLER_10_141 VGND VGND VPWR VPWR sky130_fd_sc_hd__decap_3
XFILLER_28_25 VGND VGND VPWR VPWR sky130_fd_sc_hd__decap_3
XFILLER_28_58 VGND VGND VPWR VPWR sky130_fd_sc_hd__fill_2
X_686_ _705_/A _680_/B input5/X VGND VGND VPWR VPWR _686_/Y sky130_fd_sc_hd__o21ai_4
XFILLER_18_91 VGND VGND VPWR VPWR sky130_fd_sc_hd__fill_1
Xload_slew110 _491_/A1 VGND VGND VPWR VPWR _530_/A sky130_fd_sc_hd__buf_6
X_540_ _602_/A _541_/B VGND VGND VPWR VPWR _540_/Y sky130_fd_sc_hd__nor2_2
XFILLER_29_166 VGND VGND VPWR VPWR sky130_fd_sc_hd__fill_2
XFILLER_29_111 VGND VGND VPWR VPWR sky130_fd_sc_hd__fill_1
X_471_ _471_/A _471_/B VGND VGND VPWR VPWR _472_/B sky130_fd_sc_hd__nand2_2
X_669_ _669_/A _669_/B VGND VGND VPWR VPWR _669_/Y sky130_fd_sc_hd__nand2_2
X_738_ _738_/A _738_/B VGND VGND VPWR VPWR _738_/X sky130_fd_sc_hd__and2_2
XFILLER_6_83 VGND VGND VPWR VPWR sky130_fd_sc_hd__fill_1
XFILLER_6_61 VGND VGND VPWR VPWR sky130_fd_sc_hd__decap_3
XFILLER_26_103 VGND VGND VPWR VPWR sky130_fd_sc_hd__decap_3
XFILLER_34_180 VGND VGND VPWR VPWR sky130_fd_sc_hd__decap_3
XFILLER_26_158 VGND VGND VPWR VPWR sky130_fd_sc_hd__decap_3
XFILLER_25_48 VGND VGND VPWR VPWR sky130_fd_sc_hd__decap_3
Xrebuffer167 _437_/Y VGND VGND VPWR VPWR rebuffer167/X sky130_fd_sc_hd__buf_2
Xrebuffer145 _583_/B VGND VGND VPWR VPWR _582_/B sky130_fd_sc_hd__buf_2
Xrebuffer134 _486_/A VGND VGND VPWR VPWR _461_/A sky130_fd_sc_hd__buf_2
Xrebuffer123 _711_/A VGND VGND VPWR VPWR _710_/B1 sky130_fd_sc_hd__buf_2
XFILLER_1_202 VGND VGND VPWR VPWR sky130_fd_sc_hd__decap_3
X_523_ _523_/A _523_/B _523_/C _523_/D VGND VGND VPWR VPWR _585_/B sky130_fd_sc_hd__nand4_4
XFILLER_17_169 VGND VGND VPWR VPWR sky130_fd_sc_hd__decap_3
X_454_ _667_/Y _454_/B _669_/B VGND VGND VPWR VPWR _454_/X sky130_fd_sc_hd__or3b_4
X_385_ _385_/A1 _734_/B _384_/Y VGND VGND VPWR VPWR _385_/Y sky130_fd_sc_hd__a21oi_2
XFILLER_32_139 VGND VGND VPWR VPWR sky130_fd_sc_hd__fill_1
XFILLER_25_180 VGND VGND VPWR VPWR sky130_fd_sc_hd__decap_3
XFILLER_15_81 VGND VGND VPWR VPWR sky130_fd_sc_hd__decap_3
Xoutput91 _632_/Y VGND VGND VPWR VPWR S[3] sky130_fd_sc_hd__buf_6
Xoutput80 _509_/Y VGND VGND VPWR VPWR S[22] sky130_fd_sc_hd__buf_6
XTAP_TAPCELL_ROW_33_189 VGND VPWR sky130_fd_sc_hd__tapvpwrvgnd_1
XFILLER_31_172 VGND VGND VPWR VPWR sky130_fd_sc_hd__decap_3
XFILLER_14_117 VGND VGND VPWR VPWR sky130_fd_sc_hd__decap_3
XFILLER_14_139 VGND VGND VPWR VPWR sky130_fd_sc_hd__fill_1
XFILLER_22_161 VGND VGND VPWR VPWR sky130_fd_sc_hd__decap_3
X_506_ _523_/B VGND VGND VPWR VPWR _508_/B sky130_fd_sc_hd__inv_2
XFILLER_26_91 VGND VGND VPWR VPWR sky130_fd_sc_hd__decap_3
X_437_ _436_/Y _432_/Y _434_/X VGND VGND VPWR VPWR _437_/Y sky130_fd_sc_hd__o21bai_4
X_368_ _369_/A1 _366_/B _369_/B1 VGND VGND VPWR VPWR _370_/A sky130_fd_sc_hd__o21a_4
XFILLER_9_143 VGND VGND VPWR VPWR sky130_fd_sc_hd__decap_3
XFILLER_20_109 VGND VGND VPWR VPWR sky130_fd_sc_hd__decap_3
XFILLER_11_109 VGND VGND VPWR VPWR sky130_fd_sc_hd__decap_3
XTAP_TAPCELL_ROW_21_148 VGND VPWR sky130_fd_sc_hd__tapvpwrvgnd_1
XFILLER_22_49 VGND VGND VPWR VPWR sky130_fd_sc_hd__fill_2
XFILLER_0_9 VGND VGND VPWR VPWR sky130_fd_sc_hd__decap_3
Xfanout111 fanout113/X VGND VGND VPWR VPWR _682_/A sky130_fd_sc_hd__buf_6
XPHY_EDGE_ROW_29_Right_29 VGND VGND VPWR VPWR sky130_fd_sc_hd__decap_3
XFILLER_10_131 VGND VGND VPWR VPWR sky130_fd_sc_hd__decap_3
XTAP_TAPCELL_ROW_12_115 VGND VPWR sky130_fd_sc_hd__tapvpwrvgnd_1
XFILLER_8_29 VGND VGND VPWR VPWR sky130_fd_sc_hd__fill_1
XFILLER_6_102 VGND VGND VPWR VPWR sky130_fd_sc_hd__fill_2
XFILLER_10_197 VGND VGND VPWR VPWR sky130_fd_sc_hd__decap_3
XFILLER_33_201 VGND VGND VPWR VPWR sky130_fd_sc_hd__decap_3
XFILLER_3_116 VGND VGND VPWR VPWR sky130_fd_sc_hd__decap_3
XFILLER_2_193 VGND VGND VPWR VPWR sky130_fd_sc_hd__decap_3
XFILLER_2_160 VGND VGND VPWR VPWR sky130_fd_sc_hd__decap_3
XFILLER_0_85 VGND VGND VPWR VPWR sky130_fd_sc_hd__fill_1
XFILLER_9_94 VGND VGND VPWR VPWR sky130_fd_sc_hd__fill_1
XFILLER_9_72 VGND VGND VPWR VPWR sky130_fd_sc_hd__decap_3
XFILLER_21_204 VGND VGND VPWR VPWR sky130_fd_sc_hd__decap_3
X_685_ _660_/Y _683_/B _684_/X VGND VGND VPWR VPWR _697_/C sky130_fd_sc_hd__o21ai_2
XFILLER_18_81 VGND VGND VPWR VPWR sky130_fd_sc_hd__decap_3
XFILLER_30_49 VGND VGND VPWR VPWR sky130_fd_sc_hd__decap_3
XFILLER_29_178 VGND VGND VPWR VPWR sky130_fd_sc_hd__fill_1
XFILLER_29_145 VGND VGND VPWR VPWR sky130_fd_sc_hd__decap_3
XFILLER_29_123 VGND VGND VPWR VPWR sky130_fd_sc_hd__decap_3
XFILLER_29_101 VGND VGND VPWR VPWR sky130_fd_sc_hd__decap_3
X_470_ _486_/A _471_/B VGND VGND VPWR VPWR _470_/X sky130_fd_sc_hd__and2_2
XFILLER_29_80 VGND VGND VPWR VPWR sky130_fd_sc_hd__decap_3
XFILLER_20_71 VGND VGND VPWR VPWR sky130_fd_sc_hd__decap_3
X_599_ _598_/A _598_/B _595_/Y _596_/X VGND VGND VPWR VPWR _600_/B sky130_fd_sc_hd__o2bb2ai_2
X_668_ _668_/A _668_/B VGND VGND VPWR VPWR _669_/B sky130_fd_sc_hd__or2_4
X_737_ _735_/B _734_/B _736_/Y VGND VGND VPWR VPWR _737_/X sky130_fd_sc_hd__a21o_2
XFILLER_26_137 VGND VGND VPWR VPWR sky130_fd_sc_hd__decap_3
XFILLER_26_115 VGND VGND VPWR VPWR sky130_fd_sc_hd__decap_3
XFILLER_34_192 VGND VGND VPWR VPWR sky130_fd_sc_hd__decap_3
XFILLER_25_27 VGND VGND VPWR VPWR sky130_fd_sc_hd__decap_3
Xrebuffer135 _660_/A VGND VGND VPWR VPWR _365_/A sky130_fd_sc_hd__buf_2
Xrebuffer124 _705_/X VGND VGND VPWR VPWR _710_/A1 sky130_fd_sc_hd__buf_2
X_522_ _522_/A _522_/B VGND VGND VPWR VPWR _522_/Y sky130_fd_sc_hd__nand2_2
X_453_ _479_/B _476_/B VGND VGND VPWR VPWR _458_/A sky130_fd_sc_hd__nand2_2
XFILLER_17_148 VGND VGND VPWR VPWR sky130_fd_sc_hd__decap_3
XFILLER_15_60 VGND VGND VPWR VPWR sky130_fd_sc_hd__decap_3
X_384_ _734_/B _734_/A _736_/B1 VGND VGND VPWR VPWR _384_/Y sky130_fd_sc_hd__o21bai_2
XFILLER_15_93 VGND VGND VPWR VPWR sky130_fd_sc_hd__decap_3
Xoutput70 _654_/Y VGND VGND VPWR VPWR S[13] sky130_fd_sc_hd__dlygate4sd1_1
XFILLER_31_92 VGND VGND VPWR VPWR sky130_fd_sc_hd__decap_3
Xoutput92 _634_/Y VGND VGND VPWR VPWR S[4] sky130_fd_sc_hd__buf_6
Xoutput81 _522_/Y VGND VGND VPWR VPWR S[23] sky130_fd_sc_hd__buf_6
XFILLER_23_129 VGND VGND VPWR VPWR sky130_fd_sc_hd__decap_3
XFILLER_31_184 VGND VGND VPWR VPWR sky130_fd_sc_hd__decap_3
XFILLER_14_129 VGND VGND VPWR VPWR sky130_fd_sc_hd__fill_2
XTAP_TAPCELL_ROW_24_157 VGND VPWR sky130_fd_sc_hd__tapvpwrvgnd_1
X_505_ _503_/Y _505_/B VGND VGND VPWR VPWR _523_/B sky130_fd_sc_hd__and2b_4
X_436_ _436_/A _690_/Y _436_/C VGND VGND VPWR VPWR _436_/Y sky130_fd_sc_hd__nand3_4
XFILLER_26_81 VGND VGND VPWR VPWR sky130_fd_sc_hd__decap_3
X_367_ _369_/B1 _367_/B _367_/C VGND VGND VPWR VPWR _373_/C sky130_fd_sc_hd__nand3b_4
XFILLER_9_188 VGND VGND VPWR VPWR sky130_fd_sc_hd__fill_1
XFILLER_9_122 VGND VGND VPWR VPWR sky130_fd_sc_hd__decap_3
XFILLER_3_74 VGND VGND VPWR VPWR sky130_fd_sc_hd__fill_2
XFILLER_3_96 VGND VGND VPWR VPWR sky130_fd_sc_hd__fill_2
XTAP_TAPCELL_ROW_21_149 VGND VPWR sky130_fd_sc_hd__tapvpwrvgnd_1
Xfanout101 _660_/A VGND VGND VPWR VPWR fanout101/X sky130_fd_sc_hd__buf_6
XFILLER_12_72 VGND VGND VPWR VPWR sky130_fd_sc_hd__fill_2
XTAP_TAPCELL_ROW_12_116 VGND VPWR sky130_fd_sc_hd__tapvpwrvgnd_1
XFILLER_6_169 VGND VGND VPWR VPWR sky130_fd_sc_hd__fill_2
XFILLER_26_9 VGND VGND VPWR VPWR sky130_fd_sc_hd__fill_1
X_419_ _420_/A1 _396_/Y _417_/Y VGND VGND VPWR VPWR _419_/Y sky130_fd_sc_hd__o21ai_2
XFILLER_23_93 VGND VGND VPWR VPWR sky130_fd_sc_hd__decap_3
XFILLER_23_60 VGND VGND VPWR VPWR sky130_fd_sc_hd__decap_3
XFILLER_0_42 VGND VGND VPWR VPWR sky130_fd_sc_hd__decap_3
XFILLER_9_51 VGND VGND VPWR VPWR sky130_fd_sc_hd__decap_3
XFILLER_28_49 VGND VGND VPWR VPWR sky130_fd_sc_hd__decap_3
XPHY_EDGE_ROW_8_Left_43 VGND VGND VPWR VPWR sky130_fd_sc_hd__decap_3
X_684_ _682_/A _682_/B input4/X VGND VGND VPWR VPWR _684_/X sky130_fd_sc_hd__o21a_2
XFILLER_18_60 VGND VGND VPWR VPWR sky130_fd_sc_hd__decap_3
Xload_slew112 _682_/A VGND VGND VPWR VPWR _705_/A sky130_fd_sc_hd__buf_8
XPHY_EDGE_ROW_34_Left_69 VGND VGND VPWR VPWR sky130_fd_sc_hd__decap_3
XFILLER_29_157 VGND VGND VPWR VPWR sky130_fd_sc_hd__decap_3
XFILLER_29_113 VGND VGND VPWR VPWR sky130_fd_sc_hd__decap_3
XFILLER_20_94 VGND VGND VPWR VPWR sky130_fd_sc_hd__decap_3
XFILLER_20_83 VGND VGND VPWR VPWR sky130_fd_sc_hd__fill_1
X_736_ _735_/B _734_/B _736_/B1 VGND VGND VPWR VPWR _736_/Y sky130_fd_sc_hd__o21ai_2
XFILLER_29_92 VGND VGND VPWR VPWR sky130_fd_sc_hd__decap_3
X_598_ _598_/A _598_/B _607_/B _607_/C VGND VGND VPWR VPWR _600_/A sky130_fd_sc_hd__nand4_2
X_667_ _669_/A VGND VGND VPWR VPWR _667_/Y sky130_fd_sc_hd__inv_2
XFILLER_6_52 VGND VGND VPWR VPWR sky130_fd_sc_hd__decap_3
XFILLER_6_85 VGND VGND VPWR VPWR sky130_fd_sc_hd__decap_3
XFILLER_26_127 VGND VGND VPWR VPWR sky130_fd_sc_hd__fill_2
XFILLER_25_39 VGND VGND VPWR VPWR sky130_fd_sc_hd__decap_3
Xrebuffer158 _425_/B VGND VGND VPWR VPWR _628_/A sky130_fd_sc_hd__buf_2
Xrebuffer147 _564_/A VGND VGND VPWR VPWR _560_/A2_N sky130_fd_sc_hd__buf_2
Xrebuffer136 fanout107/X VGND VGND VPWR VPWR _399_/A sky130_fd_sc_hd__buf_2
Xrebuffer125 _724_/Y VGND VGND VPWR VPWR _643_/B sky130_fd_sc_hd__buf_2
X_521_ _521_/A _521_/B _523_/C _523_/D VGND VGND VPWR VPWR _522_/B sky130_fd_sc_hd__nand4_2
X_452_ _447_/Y _448_/X _450_/C VGND VGND VPWR VPWR _476_/B sky130_fd_sc_hd__o21bai_2
X_383_ _727_/B _380_/Y _381_/X VGND VGND VPWR VPWR _383_/Y sky130_fd_sc_hd__o21ai_2
XFILLER_17_116 VGND VGND VPWR VPWR sky130_fd_sc_hd__fill_2
XFILLER_31_60 VGND VGND VPWR VPWR sky130_fd_sc_hd__fill_2
XFILLER_15_72 VGND VGND VPWR VPWR sky130_fd_sc_hd__decap_3
Xoutput93 _636_/X VGND VGND VPWR VPWR S[5] sky130_fd_sc_hd__buf_6
Xoutput82 _539_/X VGND VGND VPWR VPWR S[24] sky130_fd_sc_hd__buf_6
Xoutput71 _656_/Y VGND VGND VPWR VPWR S[14] sky130_fd_sc_hd__buf_6
X_719_ _719_/A _719_/B VGND VGND VPWR VPWR _719_/Y sky130_fd_sc_hd__nor2_2
XFILLER_14_108 VGND VGND VPWR VPWR sky130_fd_sc_hd__decap_3
XTAP_TAPCELL_ROW_24_158 VGND VPWR sky130_fd_sc_hd__tapvpwrvgnd_1
XFILLER_22_141 VGND VGND VPWR VPWR sky130_fd_sc_hd__decap_3
XFILLER_22_130 VGND VGND VPWR VPWR sky130_fd_sc_hd__decap_3
X_504_ _503_/A _503_/B input15/X VGND VGND VPWR VPWR _505_/B sky130_fd_sc_hd__o21bai_2
X_435_ _693_/Y _697_/Y _697_/B _690_/B VGND VGND VPWR VPWR _435_/X sky130_fd_sc_hd__a2bb2o_2
X_366_ _366_/A _366_/B VGND VGND VPWR VPWR _370_/B sky130_fd_sc_hd__nand2_2
XFILLER_9_134 VGND VGND VPWR VPWR sky130_fd_sc_hd__decap_3
XPHY_EDGE_ROW_21_Left_56 VGND VGND VPWR VPWR sky130_fd_sc_hd__decap_3
XFILLER_9_167 VGND VGND VPWR VPWR sky130_fd_sc_hd__fill_1
Xfanout113 fanout115/X VGND VGND VPWR VPWR fanout113/X sky130_fd_sc_hd__buf_6
XFILLER_10_100 VGND VGND VPWR VPWR sky130_fd_sc_hd__decap_3
XTAP_TAPCELL_ROW_12_117 VGND VPWR sky130_fd_sc_hd__tapvpwrvgnd_1
XFILLER_10_122 VGND VGND VPWR VPWR sky130_fd_sc_hd__decap_3
XFILLER_10_144 VGND VGND VPWR VPWR sky130_fd_sc_hd__decap_3
XFILLER_12_95 VGND VGND VPWR VPWR sky130_fd_sc_hd__decap_3
X_418_ _420_/A1 _396_/Y _417_/Y VGND VGND VPWR VPWR _418_/X sky130_fd_sc_hd__o21a_2
XFILLER_5_181 VGND VGND VPWR VPWR sky130_fd_sc_hd__decap_3
XFILLER_23_72 VGND VGND VPWR VPWR sky130_fd_sc_hd__decap_3
XFILLER_0_21 VGND VGND VPWR VPWR sky130_fd_sc_hd__decap_3
X_683_ _734_/A _683_/B VGND VGND VPWR VPWR _683_/Y sky130_fd_sc_hd__nand2_2
XFILLER_18_72 VGND VGND VPWR VPWR sky130_fd_sc_hd__decap_3
XFILLER_18_50 VGND VGND VPWR VPWR sky130_fd_sc_hd__decap_3
Xload_slew102 fanout101/X VGND VGND VPWR VPWR _369_/A1 sky130_fd_sc_hd__buf_8
XFILLER_29_136 VGND VGND VPWR VPWR sky130_fd_sc_hd__decap_3
XFILLER_29_169 VGND VGND VPWR VPWR sky130_fd_sc_hd__decap_3
X_735_ _734_/B _735_/B VGND VGND VPWR VPWR _735_/Y sky130_fd_sc_hd__nand2b_2
X_597_ _594_/A _594_/B input22/X VGND VGND VPWR VPWR _607_/C sky130_fd_sc_hd__o21bai_2
X_666_ _668_/A _668_/B VGND VGND VPWR VPWR _669_/A sky130_fd_sc_hd__nand2_4
XFILLER_6_64 VGND VGND VPWR VPWR sky130_fd_sc_hd__decap_3
XFILLER_26_106 VGND VGND VPWR VPWR sky130_fd_sc_hd__decap_3
XFILLER_25_18 VGND VGND VPWR VPWR sky130_fd_sc_hd__decap_3
XFILLER_19_191 VGND VGND VPWR VPWR sky130_fd_sc_hd__fill_1
Xrebuffer137 _369_/A1 VGND VGND VPWR VPWR _363_/B sky130_fd_sc_hd__buf_2
Xrebuffer126 _529_/B VGND VGND VPWR VPWR _537_/A1 sky130_fd_sc_hd__buf_6
XFILLER_34_183 VGND VGND VPWR VPWR sky130_fd_sc_hd__decap_3
Xrebuffer148 _437_/Y VGND VGND VPWR VPWR _467_/A2 sky130_fd_sc_hd__buf_4
XFILLER_1_205 VGND VGND VPWR VPWR sky130_fd_sc_hd__decap_3
X_520_ _521_/A _521_/B _516_/X _518_/Y VGND VGND VPWR VPWR _522_/A sky130_fd_sc_hd__o2bb2ai_2
X_451_ _447_/Y _448_/X _450_/C VGND VGND VPWR VPWR _480_/A sky130_fd_sc_hd__o21ba_2
X_382_ _706_/X _711_/C _380_/Y _382_/B2 _382_/C1 VGND VGND VPWR VPWR _433_/C sky130_fd_sc_hd__o221a_2
XFILLER_25_183 VGND VGND VPWR VPWR sky130_fd_sc_hd__decap_3
XFILLER_25_161 VGND VGND VPWR VPWR sky130_fd_sc_hd__decap_3
XFILLER_15_84 VGND VGND VPWR VPWR sky130_fd_sc_hd__decap_3
XFILLER_31_50 VGND VGND VPWR VPWR sky130_fd_sc_hd__fill_1
Xoutput94 _638_/Y VGND VGND VPWR VPWR S[6] sky130_fd_sc_hd__buf_6
Xoutput83 _550_/Y VGND VGND VPWR VPWR S[25] sky130_fd_sc_hd__buf_6
Xoutput72 _658_/X VGND VGND VPWR VPWR S[15] sky130_fd_sc_hd__clkbuf_4
X_649_ _698_/X _700_/Y _711_/B _648_/B VGND VGND VPWR VPWR _650_/B sky130_fd_sc_hd__a2bb2oi_2
X_718_ _719_/A _719_/B VGND VGND VPWR VPWR _718_/X sky130_fd_sc_hd__and2_4
XFILLER_16_150 VGND VGND VPWR VPWR sky130_fd_sc_hd__decap_3
XFILLER_31_175 VGND VGND VPWR VPWR sky130_fd_sc_hd__decap_3
XTAP_TAPCELL_ROW_24_159 VGND VPWR sky130_fd_sc_hd__tapvpwrvgnd_1
XFILLER_22_197 VGND VGND VPWR VPWR sky130_fd_sc_hd__decap_3
XFILLER_22_164 VGND VGND VPWR VPWR sky130_fd_sc_hd__decap_3
X_503_ _503_/A _503_/B input15/X VGND VGND VPWR VPWR _503_/Y sky130_fd_sc_hd__nor3b_2
XFILLER_13_164 VGND VGND VPWR VPWR sky130_fd_sc_hd__decap_3
X_434_ _697_/B _690_/B _693_/Y _697_/Y VGND VGND VPWR VPWR _434_/X sky130_fd_sc_hd__o2bb2a_2
X_365_ _365_/A _366_/B VGND VGND VPWR VPWR _365_/X sky130_fd_sc_hd__and2_2
XTAP_TAPCELL_ROW_15_126 VGND VPWR sky130_fd_sc_hd__tapvpwrvgnd_1
XFILLER_9_146 VGND VGND VPWR VPWR sky130_fd_sc_hd__decap_3
XFILLER_9_113 VGND VGND VPWR VPWR sky130_fd_sc_hd__decap_3
XFILLER_26_94 VGND VGND VPWR VPWR sky130_fd_sc_hd__decap_3
XFILLER_26_61 VGND VGND VPWR VPWR sky130_fd_sc_hd__decap_3
XFILLER_3_65 VGND VGND VPWR VPWR sky130_fd_sc_hd__decap_3
XFILLER_3_32 VGND VGND VPWR VPWR sky130_fd_sc_hd__fill_2
Xfanout103 _660_/A VGND VGND VPWR VPWR _439_/A sky130_fd_sc_hd__clkbuf_2
XFILLER_10_134 VGND VGND VPWR VPWR sky130_fd_sc_hd__decap_3
XTAP_TAPCELL_ROW_12_118 VGND VPWR sky130_fd_sc_hd__tapvpwrvgnd_1
XFILLER_12_52 VGND VGND VPWR VPWR sky130_fd_sc_hd__decap_3
XFILLER_12_63 VGND VGND VPWR VPWR sky130_fd_sc_hd__decap_3
XFILLER_12_85 VGND VGND VPWR VPWR sky130_fd_sc_hd__fill_1
XPHY_EDGE_ROW_16_Right_16 VGND VGND VPWR VPWR sky130_fd_sc_hd__decap_3
XFILLER_33_204 VGND VGND VPWR VPWR sky130_fd_sc_hd__decap_3
X_417_ _400_/A _400_/B _631_/A1 VGND VGND VPWR VPWR _417_/Y sky130_fd_sc_hd__o21bai_2
XPHY_EDGE_ROW_25_Right_25 VGND VGND VPWR VPWR sky130_fd_sc_hd__decap_3
XPHY_EDGE_ROW_34_Right_34 VGND VGND VPWR VPWR sky130_fd_sc_hd__decap_3
XFILLER_3_119 VGND VGND VPWR VPWR sky130_fd_sc_hd__fill_1
XFILLER_15_204 VGND VGND VPWR VPWR sky130_fd_sc_hd__decap_3
XFILLER_2_141 VGND VGND VPWR VPWR sky130_fd_sc_hd__decap_3
XFILLER_0_55 VGND VGND VPWR VPWR sky130_fd_sc_hd__fill_1
XFILLER_21_207 VGND VGND VPWR VPWR sky130_fd_sc_hd__fill_1
XFILLER_9_75 VGND VGND VPWR VPWR sky130_fd_sc_hd__decap_3
XFILLER_28_29 VGND VGND VPWR VPWR sky130_fd_sc_hd__decap_3
X_682_ _682_/A _682_/B VGND VGND VPWR VPWR _682_/Y sky130_fd_sc_hd__nand2_2
Xload_slew114 fanout113/X VGND VGND VPWR VPWR _719_/A sky130_fd_sc_hd__buf_4
XPHY_EDGE_ROW_2_Right_2 VGND VGND VPWR VPWR sky130_fd_sc_hd__decap_3
XFILLER_29_148 VGND VGND VPWR VPWR sky130_fd_sc_hd__decap_3
XFILLER_29_126 VGND VGND VPWR VPWR sky130_fd_sc_hd__fill_2
XFILLER_20_85 VGND VGND VPWR VPWR sky130_fd_sc_hd__decap_3
XFILLER_20_74 VGND VGND VPWR VPWR sky130_fd_sc_hd__decap_3
XFILLER_20_52 VGND VGND VPWR VPWR sky130_fd_sc_hd__fill_2
X_665_ _665_/A _665_/B VGND VGND VPWR VPWR _668_/B sky130_fd_sc_hd__xor2_4
X_734_ _734_/A _734_/B VGND VGND VPWR VPWR _734_/Y sky130_fd_sc_hd__nand2_2
XFILLER_29_83 VGND VGND VPWR VPWR sky130_fd_sc_hd__decap_3
XFILLER_28_181 VGND VGND VPWR VPWR sky130_fd_sc_hd__fill_1
XFILLER_28_170 VGND VGND VPWR VPWR sky130_fd_sc_hd__fill_2
X_596_ _594_/A _594_/B input22/X VGND VGND VPWR VPWR _596_/X sky130_fd_sc_hd__o21ba_2
XFILLER_6_43 VGND VGND VPWR VPWR sky130_fd_sc_hd__decap_3
XFILLER_26_118 VGND VGND VPWR VPWR sky130_fd_sc_hd__decap_3
XFILLER_19_181 VGND VGND VPWR VPWR sky130_fd_sc_hd__fill_1
Xrebuffer138 fanout101/X VGND VGND VPWR VPWR _409_/A sky130_fd_sc_hd__buf_2
Xrebuffer127 _523_/A VGND VGND VPWR VPWR _497_/B sky130_fd_sc_hd__buf_2
XFILLER_34_195 VGND VGND VPWR VPWR sky130_fd_sc_hd__fill_1
XFILLER_15_52 VGND VGND VPWR VPWR sky130_fd_sc_hd__decap_3
XFILLER_15_63 VGND VGND VPWR VPWR sky130_fd_sc_hd__decap_3
X_450_ _447_/Y _450_/B _450_/C VGND VGND VPWR VPWR _479_/B sky130_fd_sc_hd__nand3b_4
X_381_ _705_/X _708_/Y _711_/C _706_/X VGND VGND VPWR VPWR _381_/X sky130_fd_sc_hd__o22a_2
XTAP_TAPCELL_ROW_27_168 VGND VPWR sky130_fd_sc_hd__tapvpwrvgnd_1
XFILLER_15_96 VGND VGND VPWR VPWR sky130_fd_sc_hd__decap_3
XFILLER_31_95 VGND VGND VPWR VPWR sky130_fd_sc_hd__fill_2
Xoutput95 _640_/X VGND VGND VPWR VPWR S[7] sky130_fd_sc_hd__buf_6
Xoutput84 _563_/Y VGND VGND VPWR VPWR S[26] sky130_fd_sc_hd__buf_6
Xoutput73 _438_/X VGND VGND VPWR VPWR S[16] sky130_fd_sc_hd__buf_6
X_648_ _703_/X _648_/B VGND VGND VPWR VPWR _648_/X sky130_fd_sc_hd__xor2_2
X_717_ _714_/X _715_/Y _716_/Y VGND VGND VPWR VPWR _717_/Y sky130_fd_sc_hd__o21ai_2
X_579_ _579_/A _579_/B input21/X VGND VGND VPWR VPWR _598_/A sky130_fd_sc_hd__or3b_4
XFILLER_31_187 VGND VGND VPWR VPWR sky130_fd_sc_hd__fill_1
XFILLER_22_121 VGND VGND VPWR VPWR sky130_fd_sc_hd__decap_3
XFILLER_22_187 VGND VGND VPWR VPWR sky130_fd_sc_hd__decap_3
X_502_ _530_/A _502_/B VGND VGND VPWR VPWR _503_/B sky130_fd_sc_hd__nor2_2
X_433_ _436_/A _433_/B _433_/C _436_/C VGND VGND VPWR VPWR _652_/B sky130_fd_sc_hd__nand4_2
XFILLER_13_110 VGND VGND VPWR VPWR sky130_fd_sc_hd__fill_2
XFILLER_13_154 VGND VGND VPWR VPWR sky130_fd_sc_hd__fill_1
X_364_ _369_/A1 _366_/B VGND VGND VPWR VPWR _367_/C sky130_fd_sc_hd__nand2b_4
XTAP_TAPCELL_ROW_15_127 VGND VPWR sky130_fd_sc_hd__tapvpwrvgnd_1
XFILLER_9_169 VGND VGND VPWR VPWR sky130_fd_sc_hd__fill_2
XFILLER_9_125 VGND VGND VPWR VPWR sky130_fd_sc_hd__decap_3
Xfanout115 input65/X VGND VGND VPWR VPWR fanout115/X sky130_fd_sc_hd__buf_6
XFILLER_10_157 VGND VGND VPWR VPWR sky130_fd_sc_hd__fill_1
X_416_ _420_/A1 _416_/B _416_/C VGND VGND VPWR VPWR _416_/Y sky130_fd_sc_hd__nand3b_2
XFILLER_23_96 VGND VGND VPWR VPWR sky130_fd_sc_hd__decap_3
XFILLER_23_63 VGND VGND VPWR VPWR sky130_fd_sc_hd__decap_3
XFILLER_23_52 VGND VGND VPWR VPWR sky130_fd_sc_hd__decap_3
XFILLER_2_197 VGND VGND VPWR VPWR sky130_fd_sc_hd__decap_3
XFILLER_0_12 VGND VGND VPWR VPWR sky130_fd_sc_hd__decap_3
XFILLER_0_45 VGND VGND VPWR VPWR sky130_fd_sc_hd__fill_2
XFILLER_9_54 VGND VGND VPWR VPWR sky130_fd_sc_hd__fill_2
X_681_ _680_/Y _679_/X input5/X VGND VGND VPWR VPWR _681_/Y sky130_fd_sc_hd__o21bai_4
XFILLER_18_85 VGND VGND VPWR VPWR sky130_fd_sc_hd__decap_3
XFILLER_18_63 VGND VGND VPWR VPWR sky130_fd_sc_hd__decap_3
XFILLER_18_41 VGND VGND VPWR VPWR sky130_fd_sc_hd__fill_1
Xload_slew104 _439_/A VGND VGND VPWR VPWR _404_/A sky130_fd_sc_hd__buf_8
XFILLER_29_116 VGND VGND VPWR VPWR sky130_fd_sc_hd__fill_2
XFILLER_20_97 VGND VGND VPWR VPWR sky130_fd_sc_hd__decap_3
X_595_ _607_/B VGND VGND VPWR VPWR _595_/Y sky130_fd_sc_hd__inv_2
X_664_ _664_/A VGND VGND VPWR VPWR _664_/Y sky130_fd_sc_hd__inv_2
X_733_ _735_/B _734_/B VGND VGND VPWR VPWR _733_/X sky130_fd_sc_hd__and2b_2
XFILLER_29_95 VGND VGND VPWR VPWR sky130_fd_sc_hd__decap_3
XFILLER_6_88 VGND VGND VPWR VPWR sky130_fd_sc_hd__fill_1
XFILLER_6_77 VGND VGND VPWR VPWR sky130_fd_sc_hd__decap_3
XFILLER_6_55 VGND VGND VPWR VPWR sky130_fd_sc_hd__decap_3
XFILLER_20_3 VGND VGND VPWR VPWR sky130_fd_sc_hd__decap_3
XFILLER_34_141 VGND VGND VPWR VPWR sky130_fd_sc_hd__fill_2
Xrebuffer139 _407_/X VGND VGND VPWR VPWR _629_/B1 sky130_fd_sc_hd__buf_2
Xrebuffer128 _369_/A1 VGND VGND VPWR VPWR _366_/A sky130_fd_sc_hd__buf_2
X_380_ _714_/X _715_/Y _721_/Y _716_/Y VGND VGND VPWR VPWR _380_/Y sky130_fd_sc_hd__a2bb2oi_2
XTAP_TAPCELL_ROW_27_169 VGND VPWR sky130_fd_sc_hd__tapvpwrvgnd_1
XFILLER_25_174 VGND VGND VPWR VPWR sky130_fd_sc_hd__decap_3
XFILLER_15_75 VGND VGND VPWR VPWR sky130_fd_sc_hd__decap_3
XFILLER_31_74 VGND VGND VPWR VPWR sky130_fd_sc_hd__fill_2
X_716_ _715_/B1 _716_/B _716_/C VGND VGND VPWR VPWR _716_/Y sky130_fd_sc_hd__nand3b_2
Xoutput96 _644_/X VGND VGND VPWR VPWR S[8] sky130_fd_sc_hd__buf_6
Xoutput85 _575_/Y VGND VGND VPWR VPWR S[27] sky130_fd_sc_hd__buf_6
Xoutput74 _446_/X VGND VGND VPWR VPWR S[17] sky130_fd_sc_hd__buf_6
X_578_ _579_/A _579_/B input21/X VGND VGND VPWR VPWR _580_/A sky130_fd_sc_hd__o21bai_2
X_647_ _727_/A _643_/A _380_/Y VGND VGND VPWR VPWR _648_/B sky130_fd_sc_hd__o21ai_2
XTAP_TAPCELL_ROW_18_136 VGND VPWR sky130_fd_sc_hd__tapvpwrvgnd_1
XFILLER_31_122 VGND VGND VPWR VPWR sky130_fd_sc_hd__decap_3
XFILLER_16_141 VGND VGND VPWR VPWR sky130_fd_sc_hd__decap_3
XFILLER_31_166 VGND VGND VPWR VPWR sky130_fd_sc_hd__fill_2
.ends
