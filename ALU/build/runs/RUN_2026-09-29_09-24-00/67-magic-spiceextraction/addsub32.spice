* NGSPICE file created from addsub32.ext - technology: sky130A

* Black-box entry subcircuit for sky130_fd_sc_hd__decap_3 abstract view
.subckt sky130_fd_sc_hd__decap_3 VGND VNB VPB VPWR
.ends

* Black-box entry subcircuit for sky130_fd_sc_hd__fill_1 abstract view
.subckt sky130_fd_sc_hd__fill_1 VGND VNB VPB VPWR
.ends

* Black-box entry subcircuit for sky130_fd_sc_hd__fill_2 abstract view
.subckt sky130_fd_sc_hd__fill_2 VGND VNB VPB VPWR
.ends

* Black-box entry subcircuit for sky130_fd_sc_hd__nand2_2 abstract view
.subckt sky130_fd_sc_hd__nand2_2 A B VGND VNB VPB VPWR Y
.ends

* Black-box entry subcircuit for sky130_fd_sc_hd__xnor2_2 abstract view
.subckt sky130_fd_sc_hd__xnor2_2 A B VGND VNB VPB VPWR Y
.ends

* Black-box entry subcircuit for sky130_fd_sc_hd__nand3_2 abstract view
.subckt sky130_fd_sc_hd__nand3_2 A B C VGND VNB VPB VPWR Y
.ends

* Black-box entry subcircuit for sky130_fd_sc_hd__xor2_2 abstract view
.subckt sky130_fd_sc_hd__xor2_2 A B VGND VNB VPB VPWR X
.ends

* Black-box entry subcircuit for sky130_fd_sc_hd__o21a_4 abstract view
.subckt sky130_fd_sc_hd__o21a_4 A1 A2 B1 VGND VNB VPB VPWR X
.ends

* Black-box entry subcircuit for sky130_fd_sc_hd__or2_2 abstract view
.subckt sky130_fd_sc_hd__or2_2 A B VGND VNB VPB VPWR X
.ends

* Black-box entry subcircuit for sky130_fd_sc_hd__and2_2 abstract view
.subckt sky130_fd_sc_hd__and2_2 A B VGND VNB VPB VPWR X
.ends

* Black-box entry subcircuit for sky130_fd_sc_hd__buf_6 abstract view
.subckt sky130_fd_sc_hd__buf_6 A VGND VNB VPB VPWR X
.ends

* Black-box entry subcircuit for sky130_fd_sc_hd__tapvpwrvgnd_1 abstract view
.subckt sky130_fd_sc_hd__tapvpwrvgnd_1 VGND VPWR
.ends

* Black-box entry subcircuit for sky130_fd_sc_hd__buf_2 abstract view
.subckt sky130_fd_sc_hd__buf_2 A VGND VNB VPB VPWR X
.ends

* Black-box entry subcircuit for sky130_fd_sc_hd__clkbuf_4 abstract view
.subckt sky130_fd_sc_hd__clkbuf_4 A VGND VNB VPB VPWR X
.ends

* Black-box entry subcircuit for sky130_fd_sc_hd__buf_4 abstract view
.subckt sky130_fd_sc_hd__buf_4 A VGND VNB VPB VPWR X
.ends

* Black-box entry subcircuit for sky130_fd_sc_hd__o21ai_4 abstract view
.subckt sky130_fd_sc_hd__o21ai_4 A1 A2 B1 VGND VNB VPB VPWR Y
.ends

* Black-box entry subcircuit for sky130_fd_sc_hd__a21oi_2 abstract view
.subckt sky130_fd_sc_hd__a21oi_2 A1 A2 B1 VGND VNB VPB VPWR Y
.ends

* Black-box entry subcircuit for sky130_fd_sc_hd__buf_8 abstract view
.subckt sky130_fd_sc_hd__buf_8 A VGND VNB VPB VPWR X
.ends

* Black-box entry subcircuit for sky130_fd_sc_hd__xor2_4 abstract view
.subckt sky130_fd_sc_hd__xor2_4 A B VGND VNB VPB VPWR X
.ends

* Black-box entry subcircuit for sky130_fd_sc_hd__nand2b_2 abstract view
.subckt sky130_fd_sc_hd__nand2b_2 A_N B VGND VNB VPB VPWR Y
.ends

* Black-box entry subcircuit for sky130_fd_sc_hd__a31oi_2 abstract view
.subckt sky130_fd_sc_hd__a31oi_2 A1 A2 A3 B1 VGND VNB VPB VPWR Y
.ends

* Black-box entry subcircuit for sky130_fd_sc_hd__a22o_2 abstract view
.subckt sky130_fd_sc_hd__a22o_2 A1 A2 B1 B2 VGND VNB VPB VPWR X
.ends

* Black-box entry subcircuit for sky130_fd_sc_hd__clkbuf_2 abstract view
.subckt sky130_fd_sc_hd__clkbuf_2 A VGND VNB VPB VPWR X
.ends

* Black-box entry subcircuit for sky130_fd_sc_hd__and3_4 abstract view
.subckt sky130_fd_sc_hd__and3_4 A B C VGND VNB VPB VPWR X
.ends

* Black-box entry subcircuit for sky130_fd_sc_hd__and2_4 abstract view
.subckt sky130_fd_sc_hd__and2_4 A B VGND VNB VPB VPWR X
.ends

* Black-box entry subcircuit for sky130_fd_sc_hd__a2111o_2 abstract view
.subckt sky130_fd_sc_hd__a2111o_2 A1 A2 B1 C1 D1 VGND VNB VPB VPWR X
.ends

* Black-box entry subcircuit for sky130_fd_sc_hd__nor2_2 abstract view
.subckt sky130_fd_sc_hd__nor2_2 A B VGND VNB VPB VPWR Y
.ends

* Black-box entry subcircuit for sky130_fd_sc_hd__clkdlybuf4s25_1 abstract view
.subckt sky130_fd_sc_hd__clkdlybuf4s25_1 A VGND VNB VPB VPWR X
.ends

* Black-box entry subcircuit for sky130_fd_sc_hd__and2b_2 abstract view
.subckt sky130_fd_sc_hd__and2b_2 A_N B VGND VNB VPB VPWR X
.ends

* Black-box entry subcircuit for sky130_fd_sc_hd__o21ba_2 abstract view
.subckt sky130_fd_sc_hd__o21ba_2 A1 A2 B1_N VGND VNB VPB VPWR X
.ends

* Black-box entry subcircuit for sky130_fd_sc_hd__or2_4 abstract view
.subckt sky130_fd_sc_hd__or2_4 A B VGND VNB VPB VPWR X
.ends

* Black-box entry subcircuit for sky130_fd_sc_hd__a21oi_4 abstract view
.subckt sky130_fd_sc_hd__a21oi_4 A1 A2 B1 VGND VNB VPB VPWR Y
.ends

* Black-box entry subcircuit for sky130_fd_sc_hd__a211oi_2 abstract view
.subckt sky130_fd_sc_hd__a211oi_2 A1 A2 B1 C1 VGND VNB VPB VPWR Y
.ends

* Black-box entry subcircuit for sky130_fd_sc_hd__or3_4 abstract view
.subckt sky130_fd_sc_hd__or3_4 A B C VGND VNB VPB VPWR X
.ends

* Black-box entry subcircuit for sky130_fd_sc_hd__a21o_2 abstract view
.subckt sky130_fd_sc_hd__a21o_2 A1 A2 B1 VGND VNB VPB VPWR X
.ends

* Black-box entry subcircuit for sky130_fd_sc_hd__a211o_2 abstract view
.subckt sky130_fd_sc_hd__a211o_2 A1 A2 B1 C1 VGND VNB VPB VPWR X
.ends

* Black-box entry subcircuit for sky130_fd_sc_hd__o31a_2 abstract view
.subckt sky130_fd_sc_hd__o31a_2 A1 A2 A3 B1 VGND VNB VPB VPWR X
.ends

* Black-box entry subcircuit for sky130_fd_sc_hd__o21a_2 abstract view
.subckt sky130_fd_sc_hd__o21a_2 A1 A2 B1 VGND VNB VPB VPWR X
.ends

* Black-box entry subcircuit for sky130_fd_sc_hd__o2bb2ai_4 abstract view
.subckt sky130_fd_sc_hd__o2bb2ai_4 A1_N A2_N B1 B2 VGND VNB VPB VPWR Y
.ends

* Black-box entry subcircuit for sky130_fd_sc_hd__o21ai_2 abstract view
.subckt sky130_fd_sc_hd__o21ai_2 A1 A2 B1 VGND VNB VPB VPWR Y
.ends

* Black-box entry subcircuit for sky130_fd_sc_hd__and3_2 abstract view
.subckt sky130_fd_sc_hd__and3_2 A B C VGND VNB VPB VPWR X
.ends

* Black-box entry subcircuit for sky130_fd_sc_hd__a41o_4 abstract view
.subckt sky130_fd_sc_hd__a41o_4 A1 A2 A3 A4 B1 VGND VNB VPB VPWR X
.ends

* Black-box entry subcircuit for sky130_fd_sc_hd__dlymetal6s4s_1 abstract view
.subckt sky130_fd_sc_hd__dlymetal6s4s_1 A VGND VNB VPB VPWR X
.ends

* Black-box entry subcircuit for sky130_fd_sc_hd__xnor2_4 abstract view
.subckt sky130_fd_sc_hd__xnor2_4 A B VGND VNB VPB VPWR Y
.ends

* Black-box entry subcircuit for sky130_fd_sc_hd__o211a_2 abstract view
.subckt sky130_fd_sc_hd__o211a_2 A1 A2 B1 C1 VGND VNB VPB VPWR X
.ends

* Black-box entry subcircuit for sky130_fd_sc_hd__a31o_4 abstract view
.subckt sky130_fd_sc_hd__a31o_4 A1 A2 A3 B1 VGND VNB VPB VPWR X
.ends

* Black-box entry subcircuit for sky130_fd_sc_hd__or4b_4 abstract view
.subckt sky130_fd_sc_hd__or4b_4 A B C D_N VGND VNB VPB VPWR X
.ends

* Black-box entry subcircuit for sky130_fd_sc_hd__a21o_4 abstract view
.subckt sky130_fd_sc_hd__a21o_4 A1 A2 B1 VGND VNB VPB VPWR X
.ends

* Black-box entry subcircuit for sky130_fd_sc_hd__nand2_4 abstract view
.subckt sky130_fd_sc_hd__nand2_4 A B VGND VNB VPB VPWR Y
.ends

* Black-box entry subcircuit for sky130_fd_sc_hd__mux2_4 abstract view
.subckt sky130_fd_sc_hd__mux2_4 A0 A1 S VGND VNB VPB VPWR X
.ends

* Black-box entry subcircuit for sky130_fd_sc_hd__o211a_4 abstract view
.subckt sky130_fd_sc_hd__o211a_4 A1 A2 B1 C1 VGND VNB VPB VPWR X
.ends

* Black-box entry subcircuit for sky130_fd_sc_hd__nor3_2 abstract view
.subckt sky130_fd_sc_hd__nor3_2 A B C VGND VNB VPB VPWR Y
.ends

* Black-box entry subcircuit for sky130_fd_sc_hd__buf_12 abstract view
.subckt sky130_fd_sc_hd__buf_12 A VGND VNB VPB VPWR X
.ends

* Black-box entry subcircuit for sky130_fd_sc_hd__inv_2 abstract view
.subckt sky130_fd_sc_hd__inv_2 A VGND VNB VPB VPWR Y
.ends

* Black-box entry subcircuit for sky130_fd_sc_hd__a211o_4 abstract view
.subckt sky130_fd_sc_hd__a211o_4 A1 A2 B1 C1 VGND VNB VPB VPWR X
.ends

* Black-box entry subcircuit for sky130_fd_sc_hd__a21bo_2 abstract view
.subckt sky130_fd_sc_hd__a21bo_2 A1 A2 B1_N VGND VNB VPB VPWR X
.ends

* Black-box entry subcircuit for sky130_fd_sc_hd__or4_4 abstract view
.subckt sky130_fd_sc_hd__or4_4 A B C D VGND VNB VPB VPWR X
.ends

* Black-box entry subcircuit for sky130_fd_sc_hd__o41a_2 abstract view
.subckt sky130_fd_sc_hd__o41a_2 A1 A2 A3 A4 B1 VGND VNB VPB VPWR X
.ends

* Black-box entry subcircuit for sky130_fd_sc_hd__o22a_2 abstract view
.subckt sky130_fd_sc_hd__o22a_2 A1 A2 B1 B2 VGND VNB VPB VPWR X
.ends

* Black-box entry subcircuit for sky130_fd_sc_hd__and3b_2 abstract view
.subckt sky130_fd_sc_hd__and3b_2 A_N B C VGND VNB VPB VPWR X
.ends

.subckt addsub32 A[0] A[10] A[11] A[12] A[13] A[14] A[15] A[16] A[17] A[18] A[19]
+ A[1] A[20] A[21] A[22] A[23] A[24] A[25] A[26] A[27] A[28] A[29] A[2] A[30] A[31]
+ A[3] A[4] A[5] A[6] A[7] A[8] A[9] B[0] B[10] B[11] B[12] B[13] B[14] B[15] B[16]
+ B[17] B[18] B[19] B[1] B[20] B[21] B[22] B[23] B[24] B[25] B[26] B[27] B[28] B[29]
+ B[2] B[30] B[31] B[3] B[4] B[5] B[6] B[7] B[8] B[9] S[0] S[10] S[11] S[12] S[13]
+ S[14] S[15] S[16] S[17] S[18] S[19] S[1] S[20] S[21] S[22] S[23] S[24] S[25] S[26]
+ S[27] S[28] S[29] S[2] S[30] S[31] S[3] S[4] S[5] S[6] S[7] S[8] S[9] VGND VPWR
+ carryOut sub
XFILLER_22_111 VGND VGND VPWR VPWR sky130_fd_sc_hd__decap_3
XFILLER_13_122 VGND VGND VPWR VPWR sky130_fd_sc_hd__fill_1
XFILLER_13_133 VGND VGND VPWR VPWR sky130_fd_sc_hd__fill_2
XFILLER_9_104 VGND VGND VPWR VPWR sky130_fd_sc_hd__decap_3
X_432_ _433_/A _433_/B VGND VGND VPWR VPWR _434_/A sky130_fd_sc_hd__nand2_2
X_363_ _439_/X _363_/B VGND VGND VPWR VPWR _363_/Y sky130_fd_sc_hd__xnor2_2
X_294_ _294_/A _294_/B _294_/C VGND VGND VPWR VPWR _295_/B sky130_fd_sc_hd__nand3_2
XFILLER_12_32 VGND VGND VPWR VPWR sky130_fd_sc_hd__decap_3
XFILLER_12_76 VGND VGND VPWR VPWR sky130_fd_sc_hd__decap_3
X_415_ _415_/A _415_/B VGND VGND VPWR VPWR _416_/B sky130_fd_sc_hd__xor2_2
X_346_ _402_/C _345_/B _387_/Y VGND VGND VPWR VPWR _347_/B sky130_fd_sc_hd__o21a_4
X_277_ _277_/A _277_/B VGND VGND VPWR VPWR _279_/B sky130_fd_sc_hd__or2_2
XFILLER_23_53 VGND VGND VPWR VPWR sky130_fd_sc_hd__decap_3
XFILLER_0_57 VGND VGND VPWR VPWR sky130_fd_sc_hd__decap_3
X_329_ _329_/A _329_/B VGND VGND VPWR VPWR _330_/B sky130_fd_sc_hd__and2_2
XPHY_EDGE_ROW_8_Left_36 VGND VGND VPWR VPWR sky130_fd_sc_hd__decap_3
Xload_slew105 fanout104/X VGND VGND VPWR VPWR _411_/B sky130_fd_sc_hd__buf_6
XFILLER_20_32 VGND VGND VPWR VPWR sky130_fd_sc_hd__decap_3
XFILLER_13_3 VGND VGND VPWR VPWR sky130_fd_sc_hd__fill_1
XFILLER_6_23 VGND VGND VPWR VPWR sky130_fd_sc_hd__decap_3
XFILLER_6_56 VGND VGND VPWR VPWR sky130_fd_sc_hd__decap_3
XFILLER_15_98 VGND VGND VPWR VPWR sky130_fd_sc_hd__decap_3
XFILLER_17_109 VGND VGND VPWR VPWR sky130_fd_sc_hd__decap_3
XTAP_TAPCELL_ROW_27_126 VGND VPWR sky130_fd_sc_hd__tapvpwrvgnd_1
Xrebuffer118 input65/X VGND VGND VPWR VPWR _414_/B sky130_fd_sc_hd__buf_6
Xrebuffer129 _409_/B VGND VGND VPWR VPWR _410_/B sky130_fd_sc_hd__buf_2
XTAP_TAPCELL_ROW_18_104 VGND VPWR sky130_fd_sc_hd__tapvpwrvgnd_1
Xoutput75 _232_/X VGND VGND VPWR VPWR S[18] sky130_fd_sc_hd__clkbuf_4
Xoutput86 _313_/X VGND VGND VPWR VPWR S[28] sky130_fd_sc_hd__buf_4
Xoutput97 _356_/Y VGND VGND VPWR VPWR S[9] sky130_fd_sc_hd__buf_6
XFILLER_22_123 VGND VGND VPWR VPWR sky130_fd_sc_hd__fill_1
XTAP_TAPCELL_ROW_24_118 VGND VPWR sky130_fd_sc_hd__tapvpwrvgnd_1
XFILLER_26_75 VGND VGND VPWR VPWR sky130_fd_sc_hd__fill_1
XFILLER_3_57 VGND VGND VPWR VPWR sky130_fd_sc_hd__decap_3
XFILLER_9_116 VGND VGND VPWR VPWR sky130_fd_sc_hd__decap_3
XPHY_EDGE_ROW_21_Left_49 VGND VGND VPWR VPWR sky130_fd_sc_hd__decap_3
X_431_ _431_/A _431_/B VGND VGND VPWR VPWR _433_/B sky130_fd_sc_hd__xor2_2
X_362_ _430_/X _434_/Y _434_/A VGND VGND VPWR VPWR _363_/B sky130_fd_sc_hd__o21ai_4
X_293_ _294_/B _294_/C _294_/A VGND VGND VPWR VPWR _293_/Y sky130_fd_sc_hd__a21oi_2
XTAP_TAPCELL_ROW_12_88 VGND VPWR sky130_fd_sc_hd__tapvpwrvgnd_1
Xfanout106 input65/X VGND VGND VPWR VPWR fanout106/X sky130_fd_sc_hd__buf_8
XFILLER_12_44 VGND VGND VPWR VPWR sky130_fd_sc_hd__decap_3
XFILLER_6_108 VGND VGND VPWR VPWR sky130_fd_sc_hd__decap_3
XTAP_TAPCELL_ROW_20_110 VGND VPWR sky130_fd_sc_hd__tapvpwrvgnd_1
XTAP_TAPCELL_ROW_8_78 VGND VPWR sky130_fd_sc_hd__tapvpwrvgnd_1
X_414_ _414_/A _414_/B VGND VGND VPWR VPWR _423_/A sky130_fd_sc_hd__xor2_4
X_345_ _402_/C _345_/B VGND VGND VPWR VPWR _345_/X sky130_fd_sc_hd__xor2_2
X_276_ _271_/A _276_/B VGND VGND VPWR VPWR _277_/B sky130_fd_sc_hd__nand2b_2
XFILLER_23_32 VGND VGND VPWR VPWR sky130_fd_sc_hd__fill_2
XPHY_EDGE_ROW_12_Right_12 VGND VGND VPWR VPWR sky130_fd_sc_hd__decap_3
XPHY_EDGE_ROW_21_Right_21 VGND VGND VPWR VPWR sky130_fd_sc_hd__decap_3
XFILLER_23_76 VGND VGND VPWR VPWR sky130_fd_sc_hd__decap_3
X_328_ _308_/A _308_/B _317_/Y _319_/B VGND VGND VPWR VPWR _329_/B sky130_fd_sc_hd__a31oi_2
X_259_ _245_/A _245_/B _251_/B _251_/A VGND VGND VPWR VPWR _259_/X sky130_fd_sc_hd__a22o_2
XPHY_EDGE_ROW_24_Left_52 VGND VGND VPWR VPWR sky130_fd_sc_hd__decap_3
XFILLER_18_43 VGND VGND VPWR VPWR sky130_fd_sc_hd__decap_3
XFILLER_18_76 VGND VGND VPWR VPWR sky130_fd_sc_hd__decap_3
XFILLER_20_11 VGND VGND VPWR VPWR sky130_fd_sc_hd__fill_1
XFILLER_20_44 VGND VGND VPWR VPWR sky130_fd_sc_hd__decap_3
XFILLER_20_66 VGND VGND VPWR VPWR sky130_fd_sc_hd__decap_3
XFILLER_6_35 VGND VGND VPWR VPWR sky130_fd_sc_hd__decap_3
XFILLER_25_121 VGND VGND VPWR VPWR sky130_fd_sc_hd__decap_3
XPHY_EDGE_ROW_6_Right_6 VGND VGND VPWR VPWR sky130_fd_sc_hd__decap_3
XTAP_TAPCELL_ROW_27_127 VGND VPWR sky130_fd_sc_hd__tapvpwrvgnd_1
Xrebuffer119 _415_/A VGND VGND VPWR VPWR _412_/A sky130_fd_sc_hd__buf_2
XFILLER_15_77 VGND VGND VPWR VPWR sky130_fd_sc_hd__decap_3
XFILLER_16_110 VGND VGND VPWR VPWR sky130_fd_sc_hd__decap_3
XTAP_TAPCELL_ROW_18_105 VGND VPWR sky130_fd_sc_hd__tapvpwrvgnd_1
Xoutput76 _241_/X VGND VGND VPWR VPWR S[19] sky130_fd_sc_hd__clkbuf_2
Xoutput87 _321_/Y VGND VGND VPWR VPWR S[29] sky130_fd_sc_hd__buf_6
Xoutput98 _369_/Y VGND VGND VPWR VPWR carryOut sky130_fd_sc_hd__buf_6
XFILLER_22_102 VGND VGND VPWR VPWR sky130_fd_sc_hd__decap_3
XTAP_TAPCELL_ROW_24_119 VGND VPWR sky130_fd_sc_hd__tapvpwrvgnd_1
XFILLER_13_113 VGND VGND VPWR VPWR sky130_fd_sc_hd__decap_3
XFILLER_13_157 VGND VGND VPWR VPWR sky130_fd_sc_hd__fill_2
X_430_ _430_/A _430_/B VGND VGND VPWR VPWR _430_/X sky130_fd_sc_hd__and2_2
X_361_ _430_/X _434_/Y VGND VGND VPWR VPWR _361_/X sky130_fd_sc_hd__xor2_2
X_292_ _408_/A _292_/B VGND VGND VPWR VPWR _294_/C sky130_fd_sc_hd__nand2_2
XFILLER_3_47 VGND VGND VPWR VPWR sky130_fd_sc_hd__fill_2
XFILLER_10_105 VGND VGND VPWR VPWR sky130_fd_sc_hd__decap_3
XFILLER_12_56 VGND VGND VPWR VPWR sky130_fd_sc_hd__decap_3
XFILLER_12_67 VGND VGND VPWR VPWR sky130_fd_sc_hd__decap_3
XTAP_TAPCELL_ROW_12_89 VGND VPWR sky130_fd_sc_hd__tapvpwrvgnd_1
XFILLER_5_120 VGND VGND VPWR VPWR sky130_fd_sc_hd__decap_3
X_413_ _413_/A _413_/B _413_/C VGND VGND VPWR VPWR _426_/B sky130_fd_sc_hd__and3_4
X_344_ _428_/X _422_/X VGND VGND VPWR VPWR _344_/X sky130_fd_sc_hd__and2_4
X_275_ _275_/A _289_/A VGND VGND VPWR VPWR _281_/A sky130_fd_sc_hd__nand2_2
XTAP_TAPCELL_ROW_8_79 VGND VPWR sky130_fd_sc_hd__tapvpwrvgnd_1
XFILLER_23_44 VGND VGND VPWR VPWR sky130_fd_sc_hd__decap_3
XFILLER_9_46 VGND VGND VPWR VPWR sky130_fd_sc_hd__decap_3
XFILLER_9_79 VGND VGND VPWR VPWR sky130_fd_sc_hd__decap_3
X_327_ _311_/X _281_/C _321_/A _313_/A _310_/X VGND VGND VPWR VPWR _329_/A sky130_fd_sc_hd__a2111o_2
X_258_ _268_/A _268_/B VGND VGND VPWR VPWR _258_/Y sky130_fd_sc_hd__nor2_2
XFILLER_18_22 VGND VGND VPWR VPWR sky130_fd_sc_hd__decap_3
XFILLER_18_55 VGND VGND VPWR VPWR sky130_fd_sc_hd__decap_3
XFILLER_18_66 VGND VGND VPWR VPWR sky130_fd_sc_hd__decap_3
XFILLER_18_88 VGND VGND VPWR VPWR sky130_fd_sc_hd__decap_3
Xload_slew107 fanout106/X VGND VGND VPWR VPWR _431_/A sky130_fd_sc_hd__buf_4
XFILLER_20_56 VGND VGND VPWR VPWR sky130_fd_sc_hd__decap_3
XFILLER_6_47 VGND VGND VPWR VPWR sky130_fd_sc_hd__decap_3
XFILLER_15_45 VGND VGND VPWR VPWR sky130_fd_sc_hd__decap_3
XFILLER_15_89 VGND VGND VPWR VPWR sky130_fd_sc_hd__decap_3
XFILLER_16_122 VGND VGND VPWR VPWR sky130_fd_sc_hd__fill_2
XFILLER_16_133 VGND VGND VPWR VPWR sky130_fd_sc_hd__decap_3
XFILLER_25_166 VGND VGND VPWR VPWR sky130_fd_sc_hd__fill_1
XTAP_TAPCELL_ROW_27_128 VGND VPWR sky130_fd_sc_hd__tapvpwrvgnd_1
Xoutput66 _337_/X VGND VGND VPWR VPWR S[0] sky130_fd_sc_hd__clkdlybuf4s25_1
Xoutput77 _339_/Y VGND VGND VPWR VPWR S[1] sky130_fd_sc_hd__buf_6
Xoutput88 _341_/Y VGND VGND VPWR VPWR S[2] sky130_fd_sc_hd__buf_6
XFILLER_22_114 VGND VGND VPWR VPWR sky130_fd_sc_hd__decap_3
XFILLER_26_55 VGND VGND VPWR VPWR sky130_fd_sc_hd__decap_3
XFILLER_7_90 VGND VGND VPWR VPWR sky130_fd_sc_hd__decap_3
XFILLER_9_107 VGND VGND VPWR VPWR sky130_fd_sc_hd__decap_3
X_360_ _360_/A _382_/A VGND VGND VPWR VPWR _360_/Y sky130_fd_sc_hd__xnor2_2
X_291_ _408_/A _292_/B VGND VGND VPWR VPWR _294_/B sky130_fd_sc_hd__or2_2
XFILLER_8_162 VGND VGND VPWR VPWR sky130_fd_sc_hd__decap_3
XFILLER_12_35 VGND VGND VPWR VPWR sky130_fd_sc_hd__decap_3
XFILLER_12_79 VGND VGND VPWR VPWR sky130_fd_sc_hd__decap_3
X_412_ _412_/A _412_/B VGND VGND VPWR VPWR _413_/C sky130_fd_sc_hd__nand2_2
X_343_ _343_/A _343_/B VGND VGND VPWR VPWR _343_/Y sky130_fd_sc_hd__xnor2_2
X_274_ _274_/A _274_/B VGND VGND VPWR VPWR _289_/A sky130_fd_sc_hd__nand2_2
X_326_ _324_/Y _326_/B VGND VGND VPWR VPWR _330_/A sky130_fd_sc_hd__and2b_2
X_257_ _257_/A _257_/B VGND VGND VPWR VPWR _268_/C sky130_fd_sc_hd__xnor2_2
Xload_slew108 fanout106/X VGND VGND VPWR VPWR _386_/A sky130_fd_sc_hd__clkbuf_2
X_309_ _303_/B _304_/X _303_/A VGND VGND VPWR VPWR _311_/B sky130_fd_sc_hd__o21ba_2
XFILLER_20_24 VGND VGND VPWR VPWR sky130_fd_sc_hd__decap_3
XFILLER_20_35 VGND VGND VPWR VPWR sky130_fd_sc_hd__decap_3
XFILLER_6_26 VGND VGND VPWR VPWR sky130_fd_sc_hd__fill_2
XFILLER_6_59 VGND VGND VPWR VPWR sky130_fd_sc_hd__fill_1
XTAP_TAPCELL_ROW_27_129 VGND VPWR sky130_fd_sc_hd__tapvpwrvgnd_1
Xoutput67 _358_/X VGND VGND VPWR VPWR S[10] sky130_fd_sc_hd__buf_6
Xoutput78 _249_/Y VGND VGND VPWR VPWR S[20] sky130_fd_sc_hd__buf_6
Xoutput89 _330_/Y VGND VGND VPWR VPWR S[30] sky130_fd_sc_hd__buf_4
XFILLER_11_3 VGND VGND VPWR VPWR sky130_fd_sc_hd__fill_1
XFILLER_9_119 VGND VGND VPWR VPWR sky130_fd_sc_hd__fill_1
X_290_ _290_/A _290_/B VGND VGND VPWR VPWR _290_/Y sky130_fd_sc_hd__xnor2_2
XFILLER_12_47 VGND VGND VPWR VPWR sky130_fd_sc_hd__decap_3
X_411_ _412_/B _411_/B VGND VGND VPWR VPWR _413_/B sky130_fd_sc_hd__or2_4
X_342_ _419_/Y _340_/B _426_/A VGND VGND VPWR VPWR _343_/B sky130_fd_sc_hd__a21oi_4
X_273_ _274_/A _274_/B VGND VGND VPWR VPWR _275_/A sky130_fd_sc_hd__or2_2
XTAP_TAPCELL_ROW_0_60 VGND VPWR sky130_fd_sc_hd__tapvpwrvgnd_1
X_325_ _325_/A _325_/B _325_/C VGND VGND VPWR VPWR _326_/B sky130_fd_sc_hd__nand3_2
X_256_ _257_/A _257_/B VGND VGND VPWR VPWR _256_/Y sky130_fd_sc_hd__nand2_2
XFILLER_18_46 VGND VGND VPWR VPWR sky130_fd_sc_hd__decap_3
XFILLER_18_79 VGND VGND VPWR VPWR sky130_fd_sc_hd__decap_3
XFILLER_1_71 VGND VGND VPWR VPWR sky130_fd_sc_hd__fill_1
X_308_ _308_/A _308_/B VGND VGND VPWR VPWR _313_/A sky130_fd_sc_hd__xnor2_2
X_239_ _221_/A _221_/B _228_/B _230_/X VGND VGND VPWR VPWR _239_/Y sky130_fd_sc_hd__a211oi_2
XFILLER_20_47 VGND VGND VPWR VPWR sky130_fd_sc_hd__decap_3
XFILLER_20_69 VGND VGND VPWR VPWR sky130_fd_sc_hd__decap_3
XFILLER_10_91 VGND VGND VPWR VPWR sky130_fd_sc_hd__decap_3
XFILLER_19_110 VGND VGND VPWR VPWR sky130_fd_sc_hd__fill_2
XFILLER_6_38 VGND VGND VPWR VPWR sky130_fd_sc_hd__decap_3
XFILLER_25_124 VGND VGND VPWR VPWR sky130_fd_sc_hd__fill_1
XFILLER_16_113 VGND VGND VPWR VPWR sky130_fd_sc_hd__fill_1
XPHY_EDGE_ROW_19_Right_19 VGND VGND VPWR VPWR sky130_fd_sc_hd__decap_3
Xoutput68 _360_/Y VGND VGND VPWR VPWR S[11] sky130_fd_sc_hd__buf_6
Xoutput79 _253_/Y VGND VGND VPWR VPWR S[21] sky130_fd_sc_hd__buf_4
XFILLER_22_105 VGND VGND VPWR VPWR sky130_fd_sc_hd__decap_3
XFILLER_7_81 VGND VGND VPWR VPWR sky130_fd_sc_hd__decap_3
XPHY_EDGE_ROW_15_Left_43 VGND VGND VPWR VPWR sky130_fd_sc_hd__decap_3
XFILLER_13_116 VGND VGND VPWR VPWR sky130_fd_sc_hd__decap_3
XFILLER_10_108 VGND VGND VPWR VPWR sky130_fd_sc_hd__fill_1
XFILLER_12_59 VGND VGND VPWR VPWR sky130_fd_sc_hd__decap_3
XPHY_EDGE_ROW_0_Left_28 VGND VGND VPWR VPWR sky130_fd_sc_hd__decap_3
X_410_ _410_/A _410_/B _410_/C VGND VGND VPWR VPWR _410_/Y sky130_fd_sc_hd__nand3_2
X_341_ _341_/A _341_/B VGND VGND VPWR VPWR _341_/Y sky130_fd_sc_hd__xnor2_2
X_272_ _272_/A _272_/B VGND VGND VPWR VPWR _274_/B sky130_fd_sc_hd__xor2_2
XFILLER_5_123 VGND VGND VPWR VPWR sky130_fd_sc_hd__fill_1
XFILLER_23_47 VGND VGND VPWR VPWR sky130_fd_sc_hd__decap_3
XFILLER_2_137 VGND VGND VPWR VPWR sky130_fd_sc_hd__decap_3
XFILLER_9_38 VGND VGND VPWR VPWR sky130_fd_sc_hd__fill_1
XFILLER_9_49 VGND VGND VPWR VPWR sky130_fd_sc_hd__fill_2
XTAP_TAPCELL_ROW_13_91 VGND VPWR sky130_fd_sc_hd__tapvpwrvgnd_1
X_324_ _325_/B _325_/C _325_/A VGND VGND VPWR VPWR _324_/Y sky130_fd_sc_hd__a21oi_2
X_255_ _257_/A _257_/B VGND VGND VPWR VPWR _255_/Y sky130_fd_sc_hd__nor2_2
XTAP_TAPCELL_ROW_9_81 VGND VPWR sky130_fd_sc_hd__tapvpwrvgnd_1
XFILLER_18_25 VGND VGND VPWR VPWR sky130_fd_sc_hd__decap_3
XFILLER_18_58 VGND VGND VPWR VPWR sky130_fd_sc_hd__decap_3
XFILLER_18_69 VGND VGND VPWR VPWR sky130_fd_sc_hd__fill_1
XFILLER_1_3 VGND VGND VPWR VPWR sky130_fd_sc_hd__decap_3
XPHY_EDGE_ROW_3_Left_31 VGND VGND VPWR VPWR sky130_fd_sc_hd__decap_3
X_307_ _331_/A _307_/B VGND VGND VPWR VPWR _308_/B sky130_fd_sc_hd__xor2_2
X_238_ _238_/A _238_/B _238_/C VGND VGND VPWR VPWR _247_/B sky130_fd_sc_hd__or3_4
XFILLER_19_122 VGND VGND VPWR VPWR sky130_fd_sc_hd__decap_3
XFILLER_15_48 VGND VGND VPWR VPWR sky130_fd_sc_hd__fill_1
XFILLER_16_136 VGND VGND VPWR VPWR sky130_fd_sc_hd__decap_3
XFILLER_21_91 VGND VGND VPWR VPWR sky130_fd_sc_hd__fill_2
Xoutput69 _361_/X VGND VGND VPWR VPWR S[12] sky130_fd_sc_hd__clkbuf_4
XFILLER_22_117 VGND VGND VPWR VPWR sky130_fd_sc_hd__decap_3
XFILLER_7_60 VGND VGND VPWR VPWR sky130_fd_sc_hd__decap_3
XFILLER_7_93 VGND VGND VPWR VPWR sky130_fd_sc_hd__decap_3
XFILLER_26_25 VGND VGND VPWR VPWR sky130_fd_sc_hd__decap_3
XFILLER_16_91 VGND VGND VPWR VPWR sky130_fd_sc_hd__decap_3
XFILLER_8_165 VGND VGND VPWR VPWR sky130_fd_sc_hd__fill_2
XFILLER_12_38 VGND VGND VPWR VPWR sky130_fd_sc_hd__decap_3
X_340_ _418_/Y _340_/B VGND VGND VPWR VPWR _341_/B sky130_fd_sc_hd__nand2_2
X_271_ _271_/A _271_/B VGND VGND VPWR VPWR _271_/Y sky130_fd_sc_hd__xnor2_2
XFILLER_13_81 VGND VGND VPWR VPWR sky130_fd_sc_hd__decap_3
XFILLER_2_105 VGND VGND VPWR VPWR sky130_fd_sc_hd__fill_2
XTAP_TAPCELL_ROW_13_92 VGND VPWR sky130_fd_sc_hd__tapvpwrvgnd_1
X_323_ _323_/A _323_/B VGND VGND VPWR VPWR _325_/C sky130_fd_sc_hd__nand2_2
X_254_ _323_/A _254_/B VGND VGND VPWR VPWR _257_/B sky130_fd_sc_hd__xor2_2
XTAP_TAPCELL_ROW_9_82 VGND VPWR sky130_fd_sc_hd__tapvpwrvgnd_1
X_306_ _306_/A _306_/B VGND VGND VPWR VPWR _306_/X sky130_fd_sc_hd__xor2_2
X_237_ _235_/Y _237_/B VGND VGND VPWR VPWR _247_/A sky130_fd_sc_hd__nand2b_2
XFILLER_20_27 VGND VGND VPWR VPWR sky130_fd_sc_hd__fill_1
XFILLER_20_38 VGND VGND VPWR VPWR sky130_fd_sc_hd__decap_3
XFILLER_19_101 VGND VGND VPWR VPWR sky130_fd_sc_hd__decap_3
XFILLER_19_80 VGND VGND VPWR VPWR sky130_fd_sc_hd__decap_3
XFILLER_6_29 VGND VGND VPWR VPWR sky130_fd_sc_hd__decap_3
XFILLER_16_104 VGND VGND VPWR VPWR sky130_fd_sc_hd__decap_3
XFILLER_16_148 VGND VGND VPWR VPWR sky130_fd_sc_hd__decap_3
XPHY_EDGE_ROW_1_Right_1 VGND VGND VPWR VPWR sky130_fd_sc_hd__decap_3
XFILLER_7_72 VGND VGND VPWR VPWR sky130_fd_sc_hd__decap_3
XFILLER_26_37 VGND VGND VPWR VPWR sky130_fd_sc_hd__fill_2
X_270_ _249_/B _276_/B _278_/B VGND VGND VPWR VPWR _271_/B sky130_fd_sc_hd__a21o_2
X_399_ _384_/Y _398_/B _398_/A _382_/X VGND VGND VPWR VPWR _430_/A sky130_fd_sc_hd__a211o_2
X_322_ _323_/A _323_/B VGND VGND VPWR VPWR _325_/B sky130_fd_sc_hd__or2_2
XFILLER_13_60 VGND VGND VPWR VPWR sky130_fd_sc_hd__fill_1
X_253_ _268_/B _253_/B VGND VGND VPWR VPWR _253_/Y sky130_fd_sc_hd__xnor2_2
XFILLER_18_49 VGND VGND VPWR VPWR sky130_fd_sc_hd__decap_3
XFILLER_24_70 VGND VGND VPWR VPWR sky130_fd_sc_hd__fill_2
X_305_ _289_/B _290_/A _298_/A _304_/X VGND VGND VPWR VPWR _306_/B sky130_fd_sc_hd__o31a_2
X_236_ _236_/A _236_/B _236_/C VGND VGND VPWR VPWR _237_/B sky130_fd_sc_hd__nand3_2
XFILLER_10_83 VGND VGND VPWR VPWR sky130_fd_sc_hd__fill_1
XFILLER_10_94 VGND VGND VPWR VPWR sky130_fd_sc_hd__decap_3
XFILLER_19_113 VGND VGND VPWR VPWR sky130_fd_sc_hd__decap_3
XTAP_TAPCELL_ROW_10_83 VGND VPWR sky130_fd_sc_hd__tapvpwrvgnd_1
X_219_ _229_/A _238_/A VGND VGND VPWR VPWR _219_/X sky130_fd_sc_hd__xor2_2
XTAP_TAPCELL_ROW_6_73 VGND VPWR sky130_fd_sc_hd__tapvpwrvgnd_1
XFILLER_21_82 VGND VGND VPWR VPWR sky130_fd_sc_hd__decap_3
XFILLER_22_108 VGND VGND VPWR VPWR sky130_fd_sc_hd__decap_3
XFILLER_13_119 VGND VGND VPWR VPWR sky130_fd_sc_hd__decap_3
XFILLER_7_51 VGND VGND VPWR VPWR sky130_fd_sc_hd__decap_3
XFILLER_7_84 VGND VGND VPWR VPWR sky130_fd_sc_hd__decap_3
XPHY_EDGE_ROW_15_Right_15 VGND VGND VPWR VPWR sky130_fd_sc_hd__decap_3
XPHY_EDGE_ROW_24_Right_24 VGND VGND VPWR VPWR sky130_fd_sc_hd__decap_3
XFILLER_16_82 VGND VGND VPWR VPWR sky130_fd_sc_hd__fill_2
XFILLER_12_29 VGND VGND VPWR VPWR sky130_fd_sc_hd__decap_3
XPHY_EDGE_ROW_19_Left_47 VGND VGND VPWR VPWR sky130_fd_sc_hd__decap_3
XFILLER_4_85 VGND VGND VPWR VPWR sky130_fd_sc_hd__decap_3
X_398_ _398_/A _398_/B VGND VGND VPWR VPWR _398_/X sky130_fd_sc_hd__or2_2
XFILLER_13_72 VGND VGND VPWR VPWR sky130_fd_sc_hd__decap_3
X_321_ _321_/A _321_/B VGND VGND VPWR VPWR _321_/Y sky130_fd_sc_hd__xnor2_2
X_252_ _243_/X _249_/B _244_/X VGND VGND VPWR VPWR _253_/B sky130_fd_sc_hd__a21o_2
XFILLER_1_6 VGND VGND VPWR VPWR sky130_fd_sc_hd__decap_3
X_304_ _293_/Y _296_/X _295_/B VGND VGND VPWR VPWR _304_/X sky130_fd_sc_hd__o21a_2
X_235_ _236_/B _236_/C _236_/A VGND VGND VPWR VPWR _235_/Y sky130_fd_sc_hd__a21oi_2
XFILLER_1_97 VGND VGND VPWR VPWR sky130_fd_sc_hd__fill_2
XFILLER_20_29 VGND VGND VPWR VPWR sky130_fd_sc_hd__decap_3
XFILLER_10_51 VGND VGND VPWR VPWR sky130_fd_sc_hd__decap_3
XPHY_EDGE_ROW_7_Left_35 VGND VGND VPWR VPWR sky130_fd_sc_hd__decap_3
XTAP_TAPCELL_ROW_10_84 VGND VPWR sky130_fd_sc_hd__tapvpwrvgnd_1
XFILLER_19_60 VGND VGND VPWR VPWR sky130_fd_sc_hd__decap_3
X_218_ _218_/A _218_/B VGND VGND VPWR VPWR _238_/A sky130_fd_sc_hd__nand2_2
XTAP_TAPCELL_ROW_6_74 VGND VPWR sky130_fd_sc_hd__tapvpwrvgnd_1
XFILLER_16_139 VGND VGND VPWR VPWR sky130_fd_sc_hd__fill_1
XTAP_TAPCELL_ROW_17_101 VGND VPWR sky130_fd_sc_hd__tapvpwrvgnd_1
XTAP_TAPCELL_ROW_26_123 VGND VPWR sky130_fd_sc_hd__tapvpwrvgnd_1
XFILLER_7_30 VGND VGND VPWR VPWR sky130_fd_sc_hd__decap_3
XFILLER_7_63 VGND VGND VPWR VPWR sky130_fd_sc_hd__decap_3
XFILLER_7_96 VGND VGND VPWR VPWR sky130_fd_sc_hd__decap_3
XFILLER_12_120 VGND VGND VPWR VPWR sky130_fd_sc_hd__fill_2
XFILLER_16_94 VGND VGND VPWR VPWR sky130_fd_sc_hd__decap_3
XFILLER_8_102 VGND VGND VPWR VPWR sky130_fd_sc_hd__decap_3
XFILLER_27_60 VGND VGND VPWR VPWR sky130_fd_sc_hd__fill_2
XFILLER_4_42 VGND VGND VPWR VPWR sky130_fd_sc_hd__decap_3
XPHY_EDGE_ROW_20_Left_48 VGND VGND VPWR VPWR sky130_fd_sc_hd__decap_3
X_397_ _387_/Y _394_/X _396_/Y VGND VGND VPWR VPWR _398_/B sky130_fd_sc_hd__o21a_2
XFILLER_13_51 VGND VGND VPWR VPWR sky130_fd_sc_hd__decap_3
XFILLER_13_84 VGND VGND VPWR VPWR sky130_fd_sc_hd__decap_3
XFILLER_1_163 VGND VGND VPWR VPWR sky130_fd_sc_hd__decap_3
X_320_ _308_/A _308_/B _313_/A _313_/B VGND VGND VPWR VPWR _321_/B sky130_fd_sc_hd__o2bb2ai_4
X_251_ _251_/A _251_/B VGND VGND VPWR VPWR _268_/B sky130_fd_sc_hd__xnor2_2
XFILLER_18_29 VGND VGND VPWR VPWR sky130_fd_sc_hd__fill_2
XPHY_EDGE_ROW_23_Left_51 VGND VGND VPWR VPWR sky130_fd_sc_hd__decap_3
X_303_ _303_/A _303_/B VGND VGND VPWR VPWR _306_/A sky130_fd_sc_hd__or2_2
X_234_ _372_/A _234_/B VGND VGND VPWR VPWR _236_/C sky130_fd_sc_hd__nand2_2
XTAP_TAPCELL_ROW_10_85 VGND VPWR sky130_fd_sc_hd__tapvpwrvgnd_1
XFILLER_10_85 VGND VGND VPWR VPWR sky130_fd_sc_hd__decap_3
XFILLER_19_104 VGND VGND VPWR VPWR sky130_fd_sc_hd__decap_3
XFILLER_19_83 VGND VGND VPWR VPWR sky130_fd_sc_hd__decap_3
X_217_ _217_/A _217_/B VGND VGND VPWR VPWR _218_/B sky130_fd_sc_hd__or2_2
XTAP_TAPCELL_ROW_6_75 VGND VPWR sky130_fd_sc_hd__tapvpwrvgnd_1
XFILLER_25_3 VGND VGND VPWR VPWR sky130_fd_sc_hd__fill_1
XFILLER_16_107 VGND VGND VPWR VPWR sky130_fd_sc_hd__decap_3
XFILLER_21_40 VGND VGND VPWR VPWR sky130_fd_sc_hd__decap_3
XTAP_TAPCELL_ROW_26_124 VGND VPWR sky130_fd_sc_hd__tapvpwrvgnd_1
XFILLER_15_162 VGND VGND VPWR VPWR sky130_fd_sc_hd__decap_3
XFILLER_7_42 VGND VGND VPWR VPWR sky130_fd_sc_hd__decap_3
XFILLER_7_75 VGND VGND VPWR VPWR sky130_fd_sc_hd__decap_3
XTAP_TAPCELL_ROW_17_102 VGND VPWR sky130_fd_sc_hd__tapvpwrvgnd_1
XPHY_EDGE_ROW_5_Right_5 VGND VGND VPWR VPWR sky130_fd_sc_hd__decap_3
XTAP_TAPCELL_ROW_23_116 VGND VPWR sky130_fd_sc_hd__tapvpwrvgnd_1
XFILLER_16_51 VGND VGND VPWR VPWR sky130_fd_sc_hd__fill_1
XFILLER_16_73 VGND VGND VPWR VPWR sky130_fd_sc_hd__decap_3
XTAP_TAPCELL_ROW_20_108 VGND VPWR sky130_fd_sc_hd__tapvpwrvgnd_1
X_396_ _389_/A _389_/B _395_/X VGND VGND VPWR VPWR _396_/Y sky130_fd_sc_hd__o21ai_2
X_250_ _323_/A _250_/B VGND VGND VPWR VPWR _251_/B sky130_fd_sc_hd__xor2_2
X_448_ _447_/B _447_/C _447_/A VGND VGND VPWR VPWR _448_/Y sky130_fd_sc_hd__a21oi_2
X_379_ _381_/B _379_/B VGND VGND VPWR VPWR _379_/Y sky130_fd_sc_hd__nand2_2
X_302_ _301_/B _301_/C _301_/A VGND VGND VPWR VPWR _303_/B sky130_fd_sc_hd__a21oi_2
X_233_ _441_/A _234_/B VGND VGND VPWR VPWR _236_/B sky130_fd_sc_hd__or2_2
XFILLER_10_42 VGND VGND VPWR VPWR sky130_fd_sc_hd__decap_3
XFILLER_10_97 VGND VGND VPWR VPWR sky130_fd_sc_hd__fill_1
XFILLER_19_116 VGND VGND VPWR VPWR sky130_fd_sc_hd__decap_3
XFILLER_19_40 VGND VGND VPWR VPWR sky130_fd_sc_hd__decap_3
XFILLER_18_3 VGND VGND VPWR VPWR sky130_fd_sc_hd__decap_3
X_216_ _217_/A _217_/B VGND VGND VPWR VPWR _218_/A sky130_fd_sc_hd__nand2_2
XFILLER_16_119 VGND VGND VPWR VPWR sky130_fd_sc_hd__decap_3
XFILLER_21_52 VGND VGND VPWR VPWR sky130_fd_sc_hd__decap_3
XFILLER_21_85 VGND VGND VPWR VPWR sky130_fd_sc_hd__decap_3
XTAP_TAPCELL_ROW_26_125 VGND VPWR sky130_fd_sc_hd__tapvpwrvgnd_1
XFILLER_7_54 VGND VGND VPWR VPWR sky130_fd_sc_hd__fill_2
XFILLER_7_87 VGND VGND VPWR VPWR sky130_fd_sc_hd__decap_3
XFILLER_21_122 VGND VGND VPWR VPWR sky130_fd_sc_hd__decap_3
XTAP_TAPCELL_ROW_23_117 VGND VPWR sky130_fd_sc_hd__tapvpwrvgnd_1
XFILLER_12_111 VGND VGND VPWR VPWR sky130_fd_sc_hd__decap_3
XFILLER_16_85 VGND VGND VPWR VPWR sky130_fd_sc_hd__decap_3
XPHY_EDGE_ROW_11_Right_11 VGND VGND VPWR VPWR sky130_fd_sc_hd__decap_3
XPHY_EDGE_ROW_20_Right_20 VGND VGND VPWR VPWR sky130_fd_sc_hd__decap_3
XTAP_TAPCELL_ROW_3_66 VGND VPWR sky130_fd_sc_hd__tapvpwrvgnd_1
XTAP_TAPCELL_ROW_20_109 VGND VPWR sky130_fd_sc_hd__tapvpwrvgnd_1
XFILLER_4_162 VGND VGND VPWR VPWR sky130_fd_sc_hd__decap_3
XFILLER_4_88 VGND VGND VPWR VPWR sky130_fd_sc_hd__fill_2
X_395_ _389_/A _389_/B _393_/B _393_/A VGND VGND VPWR VPWR _395_/X sky130_fd_sc_hd__a22o_2
XFILLER_13_42 VGND VGND VPWR VPWR sky130_fd_sc_hd__decap_3
XFILLER_13_75 VGND VGND VPWR VPWR sky130_fd_sc_hd__decap_3
XTAP_TAPCELL_ROW_0_56 VGND VPWR sky130_fd_sc_hd__tapvpwrvgnd_1
X_447_ _447_/A _447_/B _447_/C VGND VGND VPWR VPWR _447_/X sky130_fd_sc_hd__and3_2
X_378_ _378_/A _378_/B VGND VGND VPWR VPWR _381_/A sky130_fd_sc_hd__xor2_4
XFILLER_24_85 VGND VGND VPWR VPWR sky130_fd_sc_hd__fill_2
X_301_ _301_/A _301_/B _301_/C VGND VGND VPWR VPWR _303_/A sky130_fd_sc_hd__and3_2
X_232_ _238_/C _232_/B VGND VGND VPWR VPWR _232_/X sky130_fd_sc_hd__xor2_2
XFILLER_10_54 VGND VGND VPWR VPWR sky130_fd_sc_hd__decap_3
XFILLER_19_52 VGND VGND VPWR VPWR sky130_fd_sc_hd__decap_3
XFILLER_19_63 VGND VGND VPWR VPWR sky130_fd_sc_hd__decap_3
X_215_ _215_/A _441_/A VGND VGND VPWR VPWR _217_/B sky130_fd_sc_hd__xor2_2
XFILLER_21_31 VGND VGND VPWR VPWR sky130_fd_sc_hd__decap_3
XFILLER_7_33 VGND VGND VPWR VPWR sky130_fd_sc_hd__decap_3
XFILLER_7_66 VGND VGND VPWR VPWR sky130_fd_sc_hd__decap_3
XFILLER_7_99 VGND VGND VPWR VPWR sky130_fd_sc_hd__decap_3
XFILLER_16_97 VGND VGND VPWR VPWR sky130_fd_sc_hd__fill_2
XFILLER_8_105 VGND VGND VPWR VPWR sky130_fd_sc_hd__decap_3
XFILLER_8_138 VGND VGND VPWR VPWR sky130_fd_sc_hd__fill_2
XTAP_TAPCELL_ROW_3_67 VGND VPWR sky130_fd_sc_hd__tapvpwrvgnd_1
XFILLER_4_12 VGND VGND VPWR VPWR sky130_fd_sc_hd__decap_3
XFILLER_4_45 VGND VGND VPWR VPWR sky130_fd_sc_hd__decap_3
X_394_ _402_/A _402_/B VGND VGND VPWR VPWR _394_/X sky130_fd_sc_hd__or2_2
XFILLER_13_54 VGND VGND VPWR VPWR sky130_fd_sc_hd__fill_2
XFILLER_1_111 VGND VGND VPWR VPWR sky130_fd_sc_hd__fill_1
XFILLER_1_166 VGND VGND VPWR VPWR sky130_fd_sc_hd__fill_1
XTAP_TAPCELL_ROW_0_57 VGND VPWR sky130_fd_sc_hd__tapvpwrvgnd_1
Xfanout99 _446_/A VGND VGND VPWR VPWR _372_/A sky130_fd_sc_hd__buf_6
X_446_ _446_/A _446_/B VGND VGND VPWR VPWR _447_/C sky130_fd_sc_hd__nand2_2
X_377_ _377_/A _377_/B VGND VGND VPWR VPWR _382_/D sky130_fd_sc_hd__xnor2_2
XFILLER_24_64 VGND VGND VPWR VPWR sky130_fd_sc_hd__decap_3
X_300_ _446_/A _300_/B VGND VGND VPWR VPWR _301_/C sky130_fd_sc_hd__nand2_2
X_231_ _221_/A _221_/B _229_/Y _230_/X VGND VGND VPWR VPWR _232_/B sky130_fd_sc_hd__a211oi_2
X_429_ _404_/Y _405_/X _422_/X _428_/X _406_/X VGND VGND VPWR VPWR _430_/B sky130_fd_sc_hd__a41o_4
XFILLER_10_88 VGND VGND VPWR VPWR sky130_fd_sc_hd__decap_3
XFILLER_19_107 VGND VGND VPWR VPWR sky130_fd_sc_hd__decap_3
XFILLER_19_31 VGND VGND VPWR VPWR sky130_fd_sc_hd__decap_3
Xinput1 A[0] VGND VGND VPWR VPWR _424_/A sky130_fd_sc_hd__dlymetal6s4s_1
XFILLER_19_86 VGND VGND VPWR VPWR sky130_fd_sc_hd__fill_2
XPHY_EDGE_ROW_11_Left_39 VGND VGND VPWR VPWR sky130_fd_sc_hd__decap_3
XPHY_EDGE_ROW_27_Left_55 VGND VGND VPWR VPWR sky130_fd_sc_hd__decap_3
X_214_ _214_/A _214_/B VGND VGND VPWR VPWR _229_/A sky130_fd_sc_hd__and2_2
XFILLER_24_110 VGND VGND VPWR VPWR sky130_fd_sc_hd__decap_3
XFILLER_15_110 VGND VGND VPWR VPWR sky130_fd_sc_hd__fill_2
XFILLER_15_165 VGND VGND VPWR VPWR sky130_fd_sc_hd__fill_2
XFILLER_21_43 VGND VGND VPWR VPWR sky130_fd_sc_hd__decap_3
XFILLER_21_76 VGND VGND VPWR VPWR sky130_fd_sc_hd__decap_3
XFILLER_21_113 VGND VGND VPWR VPWR sky130_fd_sc_hd__decap_3
XFILLER_7_45 VGND VGND VPWR VPWR sky130_fd_sc_hd__decap_3
XFILLER_7_78 VGND VGND VPWR VPWR sky130_fd_sc_hd__decap_3
XFILLER_16_76 VGND VGND VPWR VPWR sky130_fd_sc_hd__decap_3
XTAP_TAPCELL_ROW_16_98 VGND VPWR sky130_fd_sc_hd__tapvpwrvgnd_1
XPHY_EDGE_ROW_9_Right_9 VGND VGND VPWR VPWR sky130_fd_sc_hd__decap_3
XPHY_EDGE_ROW_14_Left_42 VGND VGND VPWR VPWR sky130_fd_sc_hd__decap_3
XFILLER_27_97 VGND VGND VPWR VPWR sky130_fd_sc_hd__fill_1
X_393_ _393_/A _393_/B VGND VGND VPWR VPWR _402_/B sky130_fd_sc_hd__xnor2_4
XFILLER_13_66 VGND VGND VPWR VPWR sky130_fd_sc_hd__decap_3
XTAP_TAPCELL_ROW_0_58 VGND VPWR sky130_fd_sc_hd__tapvpwrvgnd_1
X_445_ _446_/A _446_/B VGND VGND VPWR VPWR _447_/B sky130_fd_sc_hd__or2_2
X_376_ _377_/A _377_/B VGND VGND VPWR VPWR _376_/Y sky130_fd_sc_hd__nand2_2
X_230_ _221_/A _221_/B _217_/B _217_/A VGND VGND VPWR VPWR _230_/X sky130_fd_sc_hd__o211a_2
X_428_ _428_/A _428_/B _428_/C VGND VGND VPWR VPWR _428_/X sky130_fd_sc_hd__or3_4
X_359_ _382_/B _359_/A2 _373_/Y VGND VGND VPWR VPWR _360_/A sky130_fd_sc_hd__o21ai_4
XFILLER_10_45 VGND VGND VPWR VPWR sky130_fd_sc_hd__decap_3
Xinput2 A[10] VGND VGND VPWR VPWR _374_/A sky130_fd_sc_hd__clkdlybuf4s25_1
XFILLER_19_119 VGND VGND VPWR VPWR sky130_fd_sc_hd__decap_3
XFILLER_19_43 VGND VGND VPWR VPWR sky130_fd_sc_hd__decap_3
XFILLER_27_130 VGND VGND VPWR VPWR sky130_fd_sc_hd__fill_1
XFILLER_27_141 VGND VGND VPWR VPWR sky130_fd_sc_hd__decap_3
XPHY_EDGE_ROW_2_Left_30 VGND VGND VPWR VPWR sky130_fd_sc_hd__decap_3
X_213_ _448_/Y _212_/X _447_/X VGND VGND VPWR VPWR _214_/B sky130_fd_sc_hd__o21ba_2
XFILLER_18_141 VGND VGND VPWR VPWR sky130_fd_sc_hd__fill_2
XFILLER_18_6 VGND VGND VPWR VPWR sky130_fd_sc_hd__decap_3
XFILLER_21_55 VGND VGND VPWR VPWR sky130_fd_sc_hd__fill_1
XFILLER_21_88 VGND VGND VPWR VPWR sky130_fd_sc_hd__decap_3
XFILLER_24_166 VGND VGND VPWR VPWR sky130_fd_sc_hd__fill_1
XFILLER_15_122 VGND VGND VPWR VPWR sky130_fd_sc_hd__fill_2
XFILLER_15_133 VGND VGND VPWR VPWR sky130_fd_sc_hd__decap_3
XFILLER_7_57 VGND VGND VPWR VPWR sky130_fd_sc_hd__decap_3
XFILLER_12_114 VGND VGND VPWR VPWR sky130_fd_sc_hd__decap_3
XFILLER_16_11 VGND VGND VPWR VPWR sky130_fd_sc_hd__fill_1
XFILLER_16_88 VGND VGND VPWR VPWR sky130_fd_sc_hd__decap_3
XFILLER_21_125 VGND VGND VPWR VPWR sky130_fd_sc_hd__fill_2
XTAP_TAPCELL_ROW_16_99 VGND VPWR sky130_fd_sc_hd__tapvpwrvgnd_1
Xinput60 B[5] VGND VGND VPWR VPWR _390_/B sky130_fd_sc_hd__clkdlybuf4s25_1
XFILLER_7_162 VGND VGND VPWR VPWR sky130_fd_sc_hd__decap_3
XFILLER_4_165 VGND VGND VPWR VPWR sky130_fd_sc_hd__fill_2
X_392_ _393_/A _393_/B VGND VGND VPWR VPWR _392_/Y sky130_fd_sc_hd__nor2_2
XFILLER_13_45 VGND VGND VPWR VPWR sky130_fd_sc_hd__decap_3
XFILLER_13_78 VGND VGND VPWR VPWR sky130_fd_sc_hd__decap_3
XTAP_TAPCELL_ROW_0_59 VGND VPWR sky130_fd_sc_hd__tapvpwrvgnd_1
X_444_ _444_/A _444_/B VGND VGND VPWR VPWR _444_/X sky130_fd_sc_hd__or2_4
X_375_ _386_/A _375_/B VGND VGND VPWR VPWR _377_/B sky130_fd_sc_hd__xor2_2
XFILLER_24_22 VGND VGND VPWR VPWR sky130_fd_sc_hd__fill_1
XFILLER_1_48 VGND VGND VPWR VPWR sky130_fd_sc_hd__decap_3
X_427_ _427_/A _427_/B VGND VGND VPWR VPWR _428_/A sky130_fd_sc_hd__or2_4
X_358_ _382_/B _358_/B VGND VGND VPWR VPWR _358_/X sky130_fd_sc_hd__xor2_2
XPHY_EDGE_ROW_18_Right_18 VGND VGND VPWR VPWR sky130_fd_sc_hd__decap_3
XPHY_EDGE_ROW_27_Right_27 VGND VGND VPWR VPWR sky130_fd_sc_hd__decap_3
Xinput3 A[11] VGND VGND VPWR VPWR _371_/A sky130_fd_sc_hd__clkdlybuf4s25_1
X_289_ _289_/A _289_/B VGND VGND VPWR VPWR _290_/B sky130_fd_sc_hd__nand2_2
XFILLER_10_57 VGND VGND VPWR VPWR sky130_fd_sc_hd__fill_2
XFILLER_19_22 VGND VGND VPWR VPWR sky130_fd_sc_hd__decap_3
XFILLER_19_55 VGND VGND VPWR VPWR sky130_fd_sc_hd__fill_1
XFILLER_19_66 VGND VGND VPWR VPWR sky130_fd_sc_hd__decap_3
XFILLER_19_77 VGND VGND VPWR VPWR sky130_fd_sc_hd__decap_3
X_212_ _444_/A _365_/A _444_/B VGND VGND VPWR VPWR _212_/X sky130_fd_sc_hd__o21ba_2
XFILLER_21_34 VGND VGND VPWR VPWR sky130_fd_sc_hd__decap_3
XFILLER_21_67 VGND VGND VPWR VPWR sky130_fd_sc_hd__decap_3
XFILLER_15_101 VGND VGND VPWR VPWR sky130_fd_sc_hd__decap_3
XFILLER_7_36 VGND VGND VPWR VPWR sky130_fd_sc_hd__decap_3
XFILLER_7_69 VGND VGND VPWR VPWR sky130_fd_sc_hd__decap_3
Xinput50 B[25] VGND VGND VPWR VPWR _285_/B sky130_fd_sc_hd__clkdlybuf4s25_1
Xinput61 B[6] VGND VGND VPWR VPWR _388_/B sky130_fd_sc_hd__clkdlybuf4s25_1
XFILLER_16_45 VGND VGND VPWR VPWR sky130_fd_sc_hd__decap_3
XFILLER_8_108 VGND VGND VPWR VPWR sky130_fd_sc_hd__decap_3
XPHY_EDGE_ROW_0_Right_0 VGND VGND VPWR VPWR sky130_fd_sc_hd__decap_3
XFILLER_27_11 VGND VGND VPWR VPWR sky130_fd_sc_hd__fill_1
X_391_ _393_/A _393_/B VGND VGND VPWR VPWR _391_/Y sky130_fd_sc_hd__nand2_2
XFILLER_4_15 VGND VGND VPWR VPWR sky130_fd_sc_hd__decap_3
XFILLER_4_48 VGND VGND VPWR VPWR sky130_fd_sc_hd__fill_1
XFILLER_13_57 VGND VGND VPWR VPWR sky130_fd_sc_hd__decap_3
X_443_ _442_/B _442_/C _442_/A VGND VGND VPWR VPWR _444_/A sky130_fd_sc_hd__a21oi_2
X_374_ _374_/A _374_/B VGND VGND VPWR VPWR _382_/B sky130_fd_sc_hd__xnor2_2
XFILLER_24_67 VGND VGND VPWR VPWR sky130_fd_sc_hd__decap_3
Xinput4 A[12] VGND VGND VPWR VPWR _433_/A sky130_fd_sc_hd__clkdlybuf4s25_1
X_426_ _426_/A _426_/B VGND VGND VPWR VPWR _428_/B sky130_fd_sc_hd__or2_4
X_357_ _355_/B _379_/Y _376_/Y _380_/Y VGND VGND VPWR VPWR _358_/B sky130_fd_sc_hd__a31o_4
X_288_ _288_/A _288_/B VGND VGND VPWR VPWR _290_/A sky130_fd_sc_hd__nand2_2
XFILLER_10_36 VGND VGND VPWR VPWR sky130_fd_sc_hd__decap_3
XFILLER_19_34 VGND VGND VPWR VPWR sky130_fd_sc_hd__decap_3
X_211_ _434_/A _439_/B _439_/A VGND VGND VPWR VPWR _365_/A sky130_fd_sc_hd__o21ba_2
X_409_ _410_/A _409_/B _410_/C VGND VGND VPWR VPWR _427_/B sky130_fd_sc_hd__and3_4
XFILLER_21_46 VGND VGND VPWR VPWR sky130_fd_sc_hd__fill_1
XFILLER_21_79 VGND VGND VPWR VPWR sky130_fd_sc_hd__decap_3
XFILLER_15_113 VGND VGND VPWR VPWR sky130_fd_sc_hd__decap_3
XFILLER_7_48 VGND VGND VPWR VPWR sky130_fd_sc_hd__decap_3
XFILLER_21_116 VGND VGND VPWR VPWR sky130_fd_sc_hd__decap_3
Xinput40 B[16] VGND VGND VPWR VPWR _215_/A sky130_fd_sc_hd__clkdlybuf4s25_1
Xinput51 B[26] VGND VGND VPWR VPWR _292_/B sky130_fd_sc_hd__clkdlybuf4s25_1
Xinput62 B[7] VGND VGND VPWR VPWR _383_/B sky130_fd_sc_hd__clkdlybuf4s25_1
XFILLER_16_79 VGND VGND VPWR VPWR sky130_fd_sc_hd__decap_3
XFILLER_7_120 VGND VGND VPWR VPWR sky130_fd_sc_hd__decap_3
XFILLER_8_91 VGND VGND VPWR VPWR sky130_fd_sc_hd__fill_2
X_390_ _431_/A _390_/B VGND VGND VPWR VPWR _393_/B sky130_fd_sc_hd__xor2_4
XFILLER_13_69 VGND VGND VPWR VPWR sky130_fd_sc_hd__decap_3
XPHY_EDGE_ROW_18_Left_46 VGND VGND VPWR VPWR sky130_fd_sc_hd__decap_3
XTAP_TAPCELL_ROW_4_70 VGND VPWR sky130_fd_sc_hd__tapvpwrvgnd_1
X_442_ _442_/A _442_/B _442_/C VGND VGND VPWR VPWR _444_/B sky130_fd_sc_hd__and3_2
X_373_ _374_/A _374_/B VGND VGND VPWR VPWR _373_/Y sky130_fd_sc_hd__nand2_2
Xinput5 A[13] VGND VGND VPWR VPWR _437_/A sky130_fd_sc_hd__clkdlybuf4s25_1
X_425_ _425_/A _425_/B _425_/C _414_/B VGND VGND VPWR VPWR _428_/C sky130_fd_sc_hd__or4b_4
X_356_ _356_/A _356_/B VGND VGND VPWR VPWR _356_/Y sky130_fd_sc_hd__xnor2_2
X_287_ _287_/A _287_/B _287_/C VGND VGND VPWR VPWR _288_/B sky130_fd_sc_hd__nand3_2
XFILLER_10_48 VGND VGND VPWR VPWR sky130_fd_sc_hd__decap_3
XFILLER_19_46 VGND VGND VPWR VPWR sky130_fd_sc_hd__decap_3
XFILLER_19_57 VGND VGND VPWR VPWR sky130_fd_sc_hd__decap_3
X_408_ _408_/A _408_/B VGND VGND VPWR VPWR _410_/C sky130_fd_sc_hd__nand2_2
X_210_ _430_/B _430_/A _209_/X VGND VGND VPWR VPWR _214_/A sky130_fd_sc_hd__a21o_4
X_339_ _339_/A _339_/B VGND VGND VPWR VPWR _339_/Y sky130_fd_sc_hd__xnor2_2
XFILLER_15_136 VGND VGND VPWR VPWR sky130_fd_sc_hd__decap_3
XFILLER_7_27 VGND VGND VPWR VPWR sky130_fd_sc_hd__decap_3
XPHY_EDGE_ROW_6_Left_34 VGND VGND VPWR VPWR sky130_fd_sc_hd__decap_3
XFILLER_11_80 VGND VGND VPWR VPWR sky130_fd_sc_hd__decap_3
XFILLER_21_106 VGND VGND VPWR VPWR sky130_fd_sc_hd__decap_3
Xinput41 B[17] VGND VGND VPWR VPWR _220_/B sky130_fd_sc_hd__clkdlybuf4s25_1
Xinput52 B[27] VGND VGND VPWR VPWR _300_/B sky130_fd_sc_hd__clkdlybuf4s25_1
Xinput63 B[8] VGND VGND VPWR VPWR _375_/B sky130_fd_sc_hd__clkdlybuf4s25_1
Xinput30 A[7] VGND VGND VPWR VPWR _401_/A sky130_fd_sc_hd__clkdlybuf4s25_1
XFILLER_12_117 VGND VGND VPWR VPWR sky130_fd_sc_hd__decap_3
XFILLER_7_165 VGND VGND VPWR VPWR sky130_fd_sc_hd__fill_2
XFILLER_27_57 VGND VGND VPWR VPWR sky130_fd_sc_hd__decap_3
XFILLER_27_68 VGND VGND VPWR VPWR sky130_fd_sc_hd__fill_2
XFILLER_8_70 VGND VGND VPWR VPWR sky130_fd_sc_hd__decap_3
XFILLER_13_48 VGND VGND VPWR VPWR sky130_fd_sc_hd__decap_3
X_441_ _441_/A _441_/B VGND VGND VPWR VPWR _442_/C sky130_fd_sc_hd__nand2_2
X_372_ _372_/A _372_/B VGND VGND VPWR VPWR _374_/B sky130_fd_sc_hd__xor2_2
XFILLER_5_60 VGND VGND VPWR VPWR sky130_fd_sc_hd__fill_1
XFILLER_14_91 VGND VGND VPWR VPWR sky130_fd_sc_hd__decap_3
XTAP_TAPCELL_ROW_1_61 VGND VPWR sky130_fd_sc_hd__tapvpwrvgnd_1
X_424_ _424_/A _424_/B VGND VGND VPWR VPWR _425_/C sky130_fd_sc_hd__nor2_2
X_355_ _376_/Y _355_/B VGND VGND VPWR VPWR _356_/B sky130_fd_sc_hd__nand2_4
X_286_ _287_/B _287_/C _287_/A VGND VGND VPWR VPWR _288_/A sky130_fd_sc_hd__a21o_2
XFILLER_10_27 VGND VGND VPWR VPWR sky130_fd_sc_hd__fill_1
XFILLER_19_25 VGND VGND VPWR VPWR sky130_fd_sc_hd__decap_3
XFILLER_19_69 VGND VGND VPWR VPWR sky130_fd_sc_hd__fill_1
Xinput6 A[14] VGND VGND VPWR VPWR _442_/A sky130_fd_sc_hd__clkdlybuf4s25_1
XFILLER_18_112 VGND VGND VPWR VPWR sky130_fd_sc_hd__decap_3
XPHY_EDGE_ROW_14_Right_14 VGND VGND VPWR VPWR sky130_fd_sc_hd__decap_3
XPHY_EDGE_ROW_23_Right_23 VGND VGND VPWR VPWR sky130_fd_sc_hd__decap_3
XFILLER_2_72 VGND VGND VPWR VPWR sky130_fd_sc_hd__fill_2
XFILLER_2_83 VGND VGND VPWR VPWR sky130_fd_sc_hd__fill_1
XPHY_EDGE_ROW_22_Left_50 VGND VGND VPWR VPWR sky130_fd_sc_hd__decap_3
X_407_ _408_/B _411_/B VGND VGND VPWR VPWR _409_/B sky130_fd_sc_hd__or2_4
X_338_ _408_/A _424_/A _415_/B VGND VGND VPWR VPWR _339_/B sky130_fd_sc_hd__mux2_4
X_269_ _255_/Y _260_/Y _256_/Y VGND VGND VPWR VPWR _278_/B sky130_fd_sc_hd__o21ai_2
XFILLER_15_104 VGND VGND VPWR VPWR sky130_fd_sc_hd__decap_3
XFILLER_21_37 VGND VGND VPWR VPWR sky130_fd_sc_hd__decap_3
XTAP_TAPCELL_ROW_25_121 VGND VPWR sky130_fd_sc_hd__tapvpwrvgnd_1
XFILLER_7_39 VGND VGND VPWR VPWR sky130_fd_sc_hd__decap_3
Xinput31 A[8] VGND VGND VPWR VPWR _377_/A sky130_fd_sc_hd__clkdlybuf4s25_1
Xinput20 A[27] VGND VGND VPWR VPWR _301_/A sky130_fd_sc_hd__clkdlybuf4s25_1
XFILLER_16_48 VGND VGND VPWR VPWR sky130_fd_sc_hd__decap_3
XTAP_TAPCELL_ROW_22_113 VGND VPWR sky130_fd_sc_hd__tapvpwrvgnd_1
Xinput42 B[18] VGND VGND VPWR VPWR _225_/B sky130_fd_sc_hd__clkdlybuf4s25_1
Xinput53 B[28] VGND VGND VPWR VPWR _307_/B sky130_fd_sc_hd__clkdlybuf4s25_1
Xinput64 B[9] VGND VGND VPWR VPWR _378_/B sky130_fd_sc_hd__clkdlybuf4s25_1
XFILLER_11_162 VGND VGND VPWR VPWR sky130_fd_sc_hd__decap_3
XFILLER_7_111 VGND VGND VPWR VPWR sky130_fd_sc_hd__fill_1
XFILLER_8_82 VGND VGND VPWR VPWR sky130_fd_sc_hd__fill_2
XPHY_EDGE_ROW_4_Right_4 VGND VGND VPWR VPWR sky130_fd_sc_hd__decap_3
XFILLER_4_103 VGND VGND VPWR VPWR sky130_fd_sc_hd__decap_3
XFILLER_17_80 VGND VGND VPWR VPWR sky130_fd_sc_hd__decap_3
X_440_ _441_/A _441_/B VGND VGND VPWR VPWR _442_/B sky130_fd_sc_hd__or2_4
X_371_ _371_/A _371_/B VGND VGND VPWR VPWR _382_/A sky130_fd_sc_hd__xnor2_2
XFILLER_14_70 VGND VGND VPWR VPWR sky130_fd_sc_hd__decap_3
X_423_ _423_/A _423_/B VGND VGND VPWR VPWR _425_/A sky130_fd_sc_hd__xnor2_4
X_354_ _382_/D _354_/B VGND VGND VPWR VPWR _354_/X sky130_fd_sc_hd__xor2_2
X_285_ _408_/A _285_/B VGND VGND VPWR VPWR _287_/C sky130_fd_sc_hd__nand2_2
XFILLER_10_17 VGND VGND VPWR VPWR sky130_fd_sc_hd__fill_2
XFILLER_10_39 VGND VGND VPWR VPWR sky130_fd_sc_hd__decap_3
XTAP_TAPCELL_ROW_1_62 VGND VPWR sky130_fd_sc_hd__tapvpwrvgnd_1
Xinput7 A[15] VGND VGND VPWR VPWR _447_/A sky130_fd_sc_hd__clkdlybuf4s25_1
XFILLER_19_37 VGND VGND VPWR VPWR sky130_fd_sc_hd__decap_3
XFILLER_27_135 VGND VGND VPWR VPWR sky130_fd_sc_hd__fill_1
XFILLER_4_3 VGND VGND VPWR VPWR sky130_fd_sc_hd__decap_3
XFILLER_2_51 VGND VGND VPWR VPWR sky130_fd_sc_hd__decap_3
X_406_ _402_/X _382_/X _404_/Y _405_/X VGND VGND VPWR VPWR _406_/X sky130_fd_sc_hd__o211a_4
X_337_ _424_/A _415_/B VGND VGND VPWR VPWR _337_/X sky130_fd_sc_hd__xor2_2
X_268_ _268_/A _268_/B _268_/C VGND VGND VPWR VPWR _276_/B sky130_fd_sc_hd__nor3_2
XFILLER_15_116 VGND VGND VPWR VPWR sky130_fd_sc_hd__decap_3
XFILLER_11_71 VGND VGND VPWR VPWR sky130_fd_sc_hd__decap_3
XTAP_TAPCELL_ROW_16_100 VGND VPWR sky130_fd_sc_hd__tapvpwrvgnd_1
XTAP_TAPCELL_ROW_25_122 VGND VPWR sky130_fd_sc_hd__tapvpwrvgnd_1
XFILLER_20_130 VGND VGND VPWR VPWR sky130_fd_sc_hd__fill_1
XFILLER_21_119 VGND VGND VPWR VPWR sky130_fd_sc_hd__decap_3
XTAP_TAPCELL_ROW_22_114 VGND VPWR sky130_fd_sc_hd__tapvpwrvgnd_1
Xinput43 B[19] VGND VGND VPWR VPWR _234_/B sky130_fd_sc_hd__clkdlybuf4s25_1
Xinput54 B[29] VGND VGND VPWR VPWR _315_/B sky130_fd_sc_hd__clkdlybuf4s25_1
Xinput65 sub VGND VGND VPWR VPWR input65/X sky130_fd_sc_hd__buf_12
Xinput32 A[9] VGND VGND VPWR VPWR _381_/B sky130_fd_sc_hd__clkdlybuf4s25_1
Xinput21 A[28] VGND VGND VPWR VPWR _308_/A sky130_fd_sc_hd__clkdlybuf4s25_1
Xinput10 A[18] VGND VGND VPWR VPWR _227_/A sky130_fd_sc_hd__clkdlybuf4s25_1
XFILLER_11_130 VGND VGND VPWR VPWR sky130_fd_sc_hd__decap_3
XFILLER_7_123 VGND VGND VPWR VPWR sky130_fd_sc_hd__fill_1
XFILLER_17_92 VGND VGND VPWR VPWR sky130_fd_sc_hd__fill_2
XFILLER_13_39 VGND VGND VPWR VPWR sky130_fd_sc_hd__decap_3
XFILLER_1_118 VGND VGND VPWR VPWR sky130_fd_sc_hd__fill_1
X_370_ _436_/A _370_/B VGND VGND VPWR VPWR _371_/B sky130_fd_sc_hd__xor2_2
XFILLER_5_51 VGND VGND VPWR VPWR sky130_fd_sc_hd__decap_3
XTAP_TAPCELL_ROW_14_93 VGND VPWR sky130_fd_sc_hd__tapvpwrvgnd_1
X_422_ _419_/Y _426_/A _427_/A _410_/Y VGND VGND VPWR VPWR _422_/X sky130_fd_sc_hd__o31a_2
X_353_ _353_/A _382_/D VGND VGND VPWR VPWR _355_/B sky130_fd_sc_hd__or2_4
X_284_ _408_/A _285_/B VGND VGND VPWR VPWR _287_/B sky130_fd_sc_hd__or2_2
XFILLER_14_82 VGND VGND VPWR VPWR sky130_fd_sc_hd__fill_2
Xinput8 A[16] VGND VGND VPWR VPWR _217_/A sky130_fd_sc_hd__clkdlybuf4s25_1
XFILLER_19_49 VGND VGND VPWR VPWR sky130_fd_sc_hd__decap_3
XFILLER_18_103 VGND VGND VPWR VPWR sky130_fd_sc_hd__decap_3
X_405_ _376_/Y _379_/Y _380_/Y _382_/B _382_/A VGND VGND VPWR VPWR _405_/X sky130_fd_sc_hd__a2111o_2
X_336_ _336_/A _336_/B VGND VGND VPWR VPWR _336_/X sky130_fd_sc_hd__xor2_2
X_267_ _267_/A _267_/B VGND VGND VPWR VPWR _271_/A sky130_fd_sc_hd__or2_4
XFILLER_24_128 VGND VGND VPWR VPWR sky130_fd_sc_hd__fill_1
XFILLER_15_139 VGND VGND VPWR VPWR sky130_fd_sc_hd__fill_1
XFILLER_21_109 VGND VGND VPWR VPWR sky130_fd_sc_hd__decap_3
Xinput44 B[1] VGND VGND VPWR VPWR _414_/A sky130_fd_sc_hd__clkbuf_2
Xinput55 B[2] VGND VGND VPWR VPWR _412_/B sky130_fd_sc_hd__clkdlybuf4s25_1
Xinput33 B[0] VGND VGND VPWR VPWR _415_/B sky130_fd_sc_hd__clkbuf_2
Xinput22 A[29] VGND VGND VPWR VPWR _318_/A sky130_fd_sc_hd__clkdlybuf4s25_1
Xinput11 A[19] VGND VGND VPWR VPWR _236_/A sky130_fd_sc_hd__clkdlybuf4s25_1
X_319_ _319_/A _319_/B VGND VGND VPWR VPWR _321_/A sky130_fd_sc_hd__or2_2
XTAP_TAPCELL_ROW_22_115 VGND VPWR sky130_fd_sc_hd__tapvpwrvgnd_1
XFILLER_7_102 VGND VGND VPWR VPWR sky130_fd_sc_hd__decap_3
XFILLER_8_40 VGND VGND VPWR VPWR sky130_fd_sc_hd__decap_3
XFILLER_27_38 VGND VGND VPWR VPWR sky130_fd_sc_hd__fill_2
XFILLER_8_73 VGND VGND VPWR VPWR sky130_fd_sc_hd__decap_3
XFILLER_17_60 VGND VGND VPWR VPWR sky130_fd_sc_hd__fill_1
XFILLER_17_71 VGND VGND VPWR VPWR sky130_fd_sc_hd__decap_3
XFILLER_12_3 VGND VGND VPWR VPWR sky130_fd_sc_hd__decap_3
XFILLER_1_108 VGND VGND VPWR VPWR sky130_fd_sc_hd__decap_3
XFILLER_0_141 VGND VGND VPWR VPWR sky130_fd_sc_hd__fill_1
XFILLER_5_74 VGND VGND VPWR VPWR sky130_fd_sc_hd__fill_1
XTAP_TAPCELL_ROW_14_94 VGND VPWR sky130_fd_sc_hd__tapvpwrvgnd_1
X_421_ _410_/B _410_/C _410_/A VGND VGND VPWR VPWR _427_/A sky130_fd_sc_hd__a21oi_2
XFILLER_14_94 VGND VGND VPWR VPWR sky130_fd_sc_hd__decap_3
Xinput9 A[17] VGND VGND VPWR VPWR _221_/A sky130_fd_sc_hd__clkdlybuf4s25_1
X_352_ _344_/X _402_/X _384_/Y _398_/X VGND VGND VPWR VPWR _353_/A sky130_fd_sc_hd__o211a_4
X_283_ _281_/X _289_/B VGND VGND VPWR VPWR _283_/X sky130_fd_sc_hd__and2b_2
XFILLER_19_28 VGND VGND VPWR VPWR sky130_fd_sc_hd__decap_3
XFILLER_18_115 VGND VGND VPWR VPWR sky130_fd_sc_hd__fill_1
X_404_ _371_/A _371_/B _403_/X VGND VGND VPWR VPWR _404_/Y sky130_fd_sc_hd__a21oi_2
X_335_ _329_/A _326_/B _329_/B _324_/Y VGND VGND VPWR VPWR _336_/B sky130_fd_sc_hd__a31o_4
X_266_ _265_/B _265_/C _265_/A VGND VGND VPWR VPWR _267_/B sky130_fd_sc_hd__a21oi_2
XPHY_EDGE_ROW_10_Right_10 VGND VGND VPWR VPWR sky130_fd_sc_hd__decap_3
XFILLER_15_107 VGND VGND VPWR VPWR sky130_fd_sc_hd__decap_3
XPHY_EDGE_ROW_10_Left_38 VGND VGND VPWR VPWR sky130_fd_sc_hd__decap_3
XPHY_EDGE_ROW_26_Left_54 VGND VGND VPWR VPWR sky130_fd_sc_hd__decap_3
Xinput45 B[20] VGND VGND VPWR VPWR _242_/B sky130_fd_sc_hd__clkdlybuf4s25_1
Xinput56 B[30] VGND VGND VPWR VPWR _323_/B sky130_fd_sc_hd__clkdlybuf4s25_1
Xinput34 B[10] VGND VGND VPWR VPWR _372_/B sky130_fd_sc_hd__clkdlybuf4s25_1
Xinput23 A[2] VGND VGND VPWR VPWR _413_/A sky130_fd_sc_hd__clkdlybuf4s25_1
Xinput12 A[1] VGND VGND VPWR VPWR _423_/B sky130_fd_sc_hd__dlymetal6s4s_1
X_318_ _318_/A _318_/B _318_/C VGND VGND VPWR VPWR _319_/B sky130_fd_sc_hd__and3_2
X_249_ _268_/A _249_/B VGND VGND VPWR VPWR _249_/Y sky130_fd_sc_hd__xnor2_2
XFILLER_16_29 VGND VGND VPWR VPWR sky130_fd_sc_hd__decap_3
XFILLER_20_121 VGND VGND VPWR VPWR sky130_fd_sc_hd__decap_3
XFILLER_11_165 VGND VGND VPWR VPWR sky130_fd_sc_hd__fill_2
XFILLER_22_72 VGND VGND VPWR VPWR sky130_fd_sc_hd__fill_2
XFILLER_8_52 VGND VGND VPWR VPWR sky130_fd_sc_hd__decap_3
XFILLER_8_85 VGND VGND VPWR VPWR sky130_fd_sc_hd__decap_3
XFILLER_17_50 VGND VGND VPWR VPWR sky130_fd_sc_hd__decap_3
XFILLER_17_83 VGND VGND VPWR VPWR sky130_fd_sc_hd__decap_3
XFILLER_4_106 VGND VGND VPWR VPWR sky130_fd_sc_hd__decap_3
XPHY_EDGE_ROW_8_Right_8 VGND VGND VPWR VPWR sky130_fd_sc_hd__decap_3
XPHY_EDGE_ROW_13_Left_41 VGND VGND VPWR VPWR sky130_fd_sc_hd__decap_3
XFILLER_5_31 VGND VGND VPWR VPWR sky130_fd_sc_hd__fill_2
XFILLER_5_42 VGND VGND VPWR VPWR sky130_fd_sc_hd__decap_3
XFILLER_5_97 VGND VGND VPWR VPWR sky130_fd_sc_hd__fill_2
XFILLER_24_29 VGND VGND VPWR VPWR sky130_fd_sc_hd__fill_1
XTAP_TAPCELL_ROW_14_95 VGND VPWR sky130_fd_sc_hd__tapvpwrvgnd_1
XFILLER_14_51 VGND VGND VPWR VPWR sky130_fd_sc_hd__decap_3
XFILLER_14_73 VGND VGND VPWR VPWR sky130_fd_sc_hd__decap_3
X_420_ _413_/B _413_/C _413_/A VGND VGND VPWR VPWR _426_/A sky130_fd_sc_hd__a21oi_2
X_351_ _401_/Y _351_/B VGND VGND VPWR VPWR _351_/Y sky130_fd_sc_hd__xnor2_2
X_282_ _311_/A _281_/C _281_/A VGND VGND VPWR VPWR _289_/B sky130_fd_sc_hd__a21o_2
XFILLER_4_6 VGND VGND VPWR VPWR sky130_fd_sc_hd__decap_3
X_403_ _371_/A _371_/B _374_/B _374_/A VGND VGND VPWR VPWR _403_/X sky130_fd_sc_hd__o211a_2
X_334_ _334_/A _334_/B VGND VGND VPWR VPWR _336_/A sky130_fd_sc_hd__nand2_2
XFILLER_17_160 VGND VGND VPWR VPWR sky130_fd_sc_hd__decap_3
X_265_ _265_/A _265_/B _265_/C VGND VGND VPWR VPWR _267_/A sky130_fd_sc_hd__and3_2
XFILLER_11_41 VGND VGND VPWR VPWR sky130_fd_sc_hd__fill_2
XFILLER_15_119 VGND VGND VPWR VPWR sky130_fd_sc_hd__decap_3
XFILLER_11_74 VGND VGND VPWR VPWR sky130_fd_sc_hd__decap_3
XFILLER_2_3 VGND VGND VPWR VPWR sky130_fd_sc_hd__decap_3
Xinput35 B[11] VGND VGND VPWR VPWR _370_/B sky130_fd_sc_hd__clkdlybuf4s25_1
Xinput46 B[21] VGND VGND VPWR VPWR _250_/B sky130_fd_sc_hd__clkdlybuf4s25_1
Xinput57 B[31] VGND VGND VPWR VPWR _331_/B sky130_fd_sc_hd__clkdlybuf4s25_1
Xinput24 A[30] VGND VGND VPWR VPWR _325_/A sky130_fd_sc_hd__clkdlybuf4s25_1
Xinput13 A[20] VGND VGND VPWR VPWR _245_/A sky130_fd_sc_hd__clkdlybuf4s25_1
X_317_ _319_/A VGND VGND VPWR VPWR _317_/Y sky130_fd_sc_hd__inv_2
X_248_ _247_/X _229_/A _277_/A VGND VGND VPWR VPWR _249_/B sky130_fd_sc_hd__o21ai_4
XFILLER_5_54 VGND VGND VPWR VPWR sky130_fd_sc_hd__fill_2
XFILLER_14_85 VGND VGND VPWR VPWR sky130_fd_sc_hd__decap_3
X_350_ _394_/X _347_/B _396_/Y VGND VGND VPWR VPWR _351_/B sky130_fd_sc_hd__o21a_4
X_281_ _281_/A _311_/A _281_/C VGND VGND VPWR VPWR _281_/X sky130_fd_sc_hd__and3_2
XFILLER_19_19 VGND VGND VPWR VPWR sky130_fd_sc_hd__decap_3
XFILLER_18_106 VGND VGND VPWR VPWR sky130_fd_sc_hd__decap_3
XFILLER_2_22 VGND VGND VPWR VPWR sky130_fd_sc_hd__fill_1
X_402_ _402_/A _402_/B _402_/C _401_/Y VGND VGND VPWR VPWR _402_/X sky130_fd_sc_hd__or4b_4
X_333_ _333_/A _333_/B VGND VGND VPWR VPWR _334_/B sky130_fd_sc_hd__nand2_2
X_264_ _323_/A _264_/B VGND VGND VPWR VPWR _265_/C sky130_fd_sc_hd__nand2_2
XFILLER_23_120 VGND VGND VPWR VPWR sky130_fd_sc_hd__decap_3
XTAP_TAPCELL_ROW_11_86 VGND VPWR sky130_fd_sc_hd__tapvpwrvgnd_1
Xinput36 B[12] VGND VGND VPWR VPWR _431_/B sky130_fd_sc_hd__clkdlybuf4s25_1
Xinput25 A[31] VGND VGND VPWR VPWR _333_/A sky130_fd_sc_hd__clkdlybuf4s25_1
Xinput14 A[21] VGND VGND VPWR VPWR _251_/A sky130_fd_sc_hd__clkdlybuf4s25_1
X_316_ _318_/B _318_/C _318_/A VGND VGND VPWR VPWR _319_/A sky130_fd_sc_hd__a21oi_2
X_247_ _247_/A _247_/B VGND VGND VPWR VPWR _247_/X sky130_fd_sc_hd__or2_4
XTAP_TAPCELL_ROW_7_76 VGND VPWR sky130_fd_sc_hd__tapvpwrvgnd_1
XFILLER_20_112 VGND VGND VPWR VPWR sky130_fd_sc_hd__decap_3
Xinput47 B[22] VGND VGND VPWR VPWR _254_/B sky130_fd_sc_hd__clkdlybuf4s25_1
Xinput58 B[3] VGND VGND VPWR VPWR _408_/B sky130_fd_sc_hd__clkdlybuf4s25_1
XFILLER_22_85 VGND VGND VPWR VPWR sky130_fd_sc_hd__decap_3
XFILLER_7_105 VGND VGND VPWR VPWR sky130_fd_sc_hd__decap_3
XFILLER_8_43 VGND VGND VPWR VPWR sky130_fd_sc_hd__decap_3
XFILLER_8_76 VGND VGND VPWR VPWR sky130_fd_sc_hd__decap_3
XFILLER_12_6 VGND VGND VPWR VPWR sky130_fd_sc_hd__decap_3
XFILLER_17_74 VGND VGND VPWR VPWR sky130_fd_sc_hd__decap_3
XFILLER_0_111 VGND VGND VPWR VPWR sky130_fd_sc_hd__fill_1
XFILLER_0_155 VGND VGND VPWR VPWR sky130_fd_sc_hd__decap_3
XFILLER_5_22 VGND VGND VPWR VPWR sky130_fd_sc_hd__fill_2
XFILLER_14_42 VGND VGND VPWR VPWR sky130_fd_sc_hd__decap_3
XFILLER_14_97 VGND VGND VPWR VPWR sky130_fd_sc_hd__decap_3
X_280_ _214_/B _214_/A _247_/X _277_/B VGND VGND VPWR VPWR _281_/C sky130_fd_sc_hd__a211o_4
XFILLER_25_63 VGND VGND VPWR VPWR sky130_fd_sc_hd__decap_3
X_401_ _401_/A _401_/B VGND VGND VPWR VPWR _401_/Y sky130_fd_sc_hd__xnor2_2
X_332_ _333_/A _333_/B VGND VGND VPWR VPWR _334_/A sky130_fd_sc_hd__or2_2
X_263_ _323_/A _264_/B VGND VGND VPWR VPWR _265_/B sky130_fd_sc_hd__or2_2
XTAP_TAPCELL_ROW_11_87 VGND VPWR sky130_fd_sc_hd__tapvpwrvgnd_1
XFILLER_11_32 VGND VGND VPWR VPWR sky130_fd_sc_hd__decap_3
XFILLER_14_154 VGND VGND VPWR VPWR sky130_fd_sc_hd__decap_3
XFILLER_23_154 VGND VGND VPWR VPWR sky130_fd_sc_hd__decap_3
XTAP_TAPCELL_ROW_7_77 VGND VPWR sky130_fd_sc_hd__tapvpwrvgnd_1
XFILLER_20_124 VGND VGND VPWR VPWR sky130_fd_sc_hd__decap_3
XFILLER_20_157 VGND VGND VPWR VPWR sky130_fd_sc_hd__fill_2
Xinput37 B[13] VGND VGND VPWR VPWR _436_/B sky130_fd_sc_hd__clkdlybuf4s25_1
Xinput48 B[23] VGND VGND VPWR VPWR _264_/B sky130_fd_sc_hd__clkdlybuf4s25_1
Xinput59 B[4] VGND VGND VPWR VPWR _386_/B sky130_fd_sc_hd__clkdlybuf4s25_1
Xinput26 A[3] VGND VGND VPWR VPWR _410_/A sky130_fd_sc_hd__clkdlybuf4s25_1
Xinput15 A[22] VGND VGND VPWR VPWR _257_/A sky130_fd_sc_hd__clkdlybuf4s25_1
X_315_ _331_/A _315_/B VGND VGND VPWR VPWR _318_/C sky130_fd_sc_hd__nand2_2
X_246_ _228_/A _235_/Y _239_/Y _237_/B VGND VGND VPWR VPWR _277_/A sky130_fd_sc_hd__o31a_2
XFILLER_8_55 VGND VGND VPWR VPWR sky130_fd_sc_hd__decap_3
XFILLER_8_88 VGND VGND VPWR VPWR sky130_fd_sc_hd__decap_3
XFILLER_8_99 VGND VGND VPWR VPWR sky130_fd_sc_hd__decap_3
X_229_ _229_/A _238_/A _238_/B VGND VGND VPWR VPWR _229_/Y sky130_fd_sc_hd__nor3_2
XFILLER_4_109 VGND VGND VPWR VPWR sky130_fd_sc_hd__decap_3
XFILLER_17_53 VGND VGND VPWR VPWR sky130_fd_sc_hd__decap_3
XFILLER_17_86 VGND VGND VPWR VPWR sky130_fd_sc_hd__decap_3
XPHY_EDGE_ROW_17_Right_17 VGND VGND VPWR VPWR sky130_fd_sc_hd__decap_3
XPHY_EDGE_ROW_26_Right_26 VGND VGND VPWR VPWR sky130_fd_sc_hd__decap_3
XFILLER_5_45 VGND VGND VPWR VPWR sky130_fd_sc_hd__decap_3
XFILLER_14_54 VGND VGND VPWR VPWR sky130_fd_sc_hd__decap_3
XFILLER_14_76 VGND VGND VPWR VPWR sky130_fd_sc_hd__decap_3
XPHY_EDGE_ROW_17_Left_45 VGND VGND VPWR VPWR sky130_fd_sc_hd__decap_3
XFILLER_25_31 VGND VGND VPWR VPWR sky130_fd_sc_hd__decap_3
XFILLER_26_141 VGND VGND VPWR VPWR sky130_fd_sc_hd__decap_3
XFILLER_4_9 VGND VGND VPWR VPWR sky130_fd_sc_hd__decap_3
X_400_ _400_/A _400_/B VGND VGND VPWR VPWR _402_/C sky130_fd_sc_hd__xnor2_2
X_331_ _331_/A _331_/B VGND VGND VPWR VPWR _333_/B sky130_fd_sc_hd__xor2_2
X_262_ _268_/C _262_/B VGND VGND VPWR VPWR _262_/Y sky130_fd_sc_hd__xnor2_2
XFILLER_17_141 VGND VGND VPWR VPWR sky130_fd_sc_hd__fill_1
XFILLER_17_163 VGND VGND VPWR VPWR sky130_fd_sc_hd__decap_3
XFILLER_2_35 VGND VGND VPWR VPWR sky130_fd_sc_hd__decap_3
XFILLER_11_77 VGND VGND VPWR VPWR sky130_fd_sc_hd__decap_3
XFILLER_2_6 VGND VGND VPWR VPWR sky130_fd_sc_hd__decap_3
XFILLER_14_100 VGND VGND VPWR VPWR sky130_fd_sc_hd__decap_3
Xinput38 B[14] VGND VGND VPWR VPWR _441_/B sky130_fd_sc_hd__clkdlybuf4s25_1
Xinput49 B[24] VGND VGND VPWR VPWR _272_/B sky130_fd_sc_hd__clkdlybuf4s25_1
Xinput27 A[4] VGND VGND VPWR VPWR _400_/A sky130_fd_sc_hd__clkdlybuf4s25_1
Xinput16 A[23] VGND VGND VPWR VPWR _265_/A sky130_fd_sc_hd__clkdlybuf4s25_1
X_314_ _331_/A _315_/B VGND VGND VPWR VPWR _318_/B sky130_fd_sc_hd__or2_2
X_245_ _245_/A _245_/B VGND VGND VPWR VPWR _268_/A sky130_fd_sc_hd__xnor2_2
XFILLER_11_147 VGND VGND VPWR VPWR sky130_fd_sc_hd__fill_2
XFILLER_8_67 VGND VGND VPWR VPWR sky130_fd_sc_hd__decap_3
XPHY_EDGE_ROW_5_Left_33 VGND VGND VPWR VPWR sky130_fd_sc_hd__decap_3
XFILLER_6_162 VGND VGND VPWR VPWR sky130_fd_sc_hd__decap_3
X_228_ _228_/A _228_/B VGND VGND VPWR VPWR _238_/C sky130_fd_sc_hd__or2_4
XTAP_TAPCELL_ROW_4_68 VGND VPWR sky130_fd_sc_hd__tapvpwrvgnd_1
XFILLER_5_57 VGND VGND VPWR VPWR sky130_fd_sc_hd__decap_3
XFILLER_14_11 VGND VGND VPWR VPWR sky130_fd_sc_hd__decap_3
XFILLER_14_88 VGND VGND VPWR VPWR sky130_fd_sc_hd__decap_3
XFILLER_18_109 VGND VGND VPWR VPWR sky130_fd_sc_hd__decap_3
XFILLER_25_54 VGND VGND VPWR VPWR sky130_fd_sc_hd__fill_2
X_330_ _330_/A _330_/B VGND VGND VPWR VPWR _330_/Y sky130_fd_sc_hd__xnor2_2
X_261_ _249_/B _258_/Y _260_/Y VGND VGND VPWR VPWR _262_/B sky130_fd_sc_hd__a21bo_2
XFILLER_2_69 VGND VGND VPWR VPWR sky130_fd_sc_hd__decap_3
XFILLER_23_123 VGND VGND VPWR VPWR sky130_fd_sc_hd__fill_1
Xinput39 B[15] VGND VGND VPWR VPWR _446_/B sky130_fd_sc_hd__clkdlybuf4s25_1
Xinput28 A[5] VGND VGND VPWR VPWR _393_/A sky130_fd_sc_hd__clkdlybuf4s25_1
Xinput17 A[24] VGND VGND VPWR VPWR _274_/A sky130_fd_sc_hd__clkdlybuf4s25_1
X_313_ _313_/A _313_/B VGND VGND VPWR VPWR _313_/X sky130_fd_sc_hd__xor2_2
X_244_ _245_/A _245_/B VGND VGND VPWR VPWR _244_/X sky130_fd_sc_hd__and2_2
XFILLER_20_115 VGND VGND VPWR VPWR sky130_fd_sc_hd__decap_3
XFILLER_22_66 VGND VGND VPWR VPWR sky130_fd_sc_hd__decap_3
XFILLER_22_88 VGND VGND VPWR VPWR sky130_fd_sc_hd__fill_1
XFILLER_7_108 VGND VGND VPWR VPWR sky130_fd_sc_hd__decap_3
XFILLER_6_130 VGND VGND VPWR VPWR sky130_fd_sc_hd__fill_1
XFILLER_8_46 VGND VGND VPWR VPWR sky130_fd_sc_hd__decap_3
XFILLER_8_79 VGND VGND VPWR VPWR sky130_fd_sc_hd__decap_3
X_227_ _227_/A _227_/B _227_/C VGND VGND VPWR VPWR _228_/B sky130_fd_sc_hd__and3_2
XFILLER_17_77 VGND VGND VPWR VPWR sky130_fd_sc_hd__decap_3
XTAP_TAPCELL_ROW_4_69 VGND VPWR sky130_fd_sc_hd__tapvpwrvgnd_1
XFILLER_3_111 VGND VGND VPWR VPWR sky130_fd_sc_hd__fill_1
XFILLER_3_166 VGND VGND VPWR VPWR sky130_fd_sc_hd__fill_1
XPHY_EDGE_ROW_3_Right_3 VGND VGND VPWR VPWR sky130_fd_sc_hd__decap_3
XFILLER_14_45 VGND VGND VPWR VPWR sky130_fd_sc_hd__decap_3
XFILLER_14_67 VGND VGND VPWR VPWR sky130_fd_sc_hd__decap_3
XFILLER_6_90 VGND VGND VPWR VPWR sky130_fd_sc_hd__decap_3
X_260_ _251_/A _251_/B _259_/X VGND VGND VPWR VPWR _260_/Y sky130_fd_sc_hd__o21ai_2
Xrebuffer130 _426_/B VGND VGND VPWR VPWR _419_/C1 sky130_fd_sc_hd__buf_2
X_389_ _389_/A _389_/B VGND VGND VPWR VPWR _402_/A sky130_fd_sc_hd__xnor2_4
XFILLER_11_35 VGND VGND VPWR VPWR sky130_fd_sc_hd__decap_3
XFILLER_14_157 VGND VGND VPWR VPWR sky130_fd_sc_hd__fill_2
Xinput29 A[6] VGND VGND VPWR VPWR _389_/A sky130_fd_sc_hd__clkdlybuf4s25_1
Xinput18 A[25] VGND VGND VPWR VPWR _287_/A sky130_fd_sc_hd__clkdlybuf4s25_1
X_312_ _281_/C _311_/X _310_/X VGND VGND VPWR VPWR _313_/B sky130_fd_sc_hd__a21o_2
X_243_ _245_/A _245_/B VGND VGND VPWR VPWR _243_/X sky130_fd_sc_hd__or2_2
XFILLER_20_127 VGND VGND VPWR VPWR sky130_fd_sc_hd__decap_3
XFILLER_9_161 VGND VGND VPWR VPWR sky130_fd_sc_hd__decap_3
XTAP_TAPCELL_ROW_21_111 VGND VPWR sky130_fd_sc_hd__tapvpwrvgnd_1
XFILLER_8_58 VGND VGND VPWR VPWR sky130_fd_sc_hd__fill_2
X_226_ _227_/B _227_/C _227_/A VGND VGND VPWR VPWR _228_/A sky130_fd_sc_hd__a21oi_2
XFILLER_17_89 VGND VGND VPWR VPWR sky130_fd_sc_hd__decap_3
XFILLER_0_92 VGND VGND VPWR VPWR sky130_fd_sc_hd__decap_3
X_209_ _434_/Y _439_/X _444_/X _368_/A VGND VGND VPWR VPWR _209_/X sky130_fd_sc_hd__or4_4
XFILLER_0_137 VGND VGND VPWR VPWR sky130_fd_sc_hd__decap_3
XFILLER_5_48 VGND VGND VPWR VPWR sky130_fd_sc_hd__decap_3
XPHY_EDGE_ROW_13_Right_13 VGND VGND VPWR VPWR sky130_fd_sc_hd__decap_3
XPHY_EDGE_ROW_22_Right_22 VGND VGND VPWR VPWR sky130_fd_sc_hd__decap_3
XFILLER_14_57 VGND VGND VPWR VPWR sky130_fd_sc_hd__decap_3
XFILLER_14_79 VGND VGND VPWR VPWR sky130_fd_sc_hd__decap_3
XFILLER_26_122 VGND VGND VPWR VPWR sky130_fd_sc_hd__fill_1
XFILLER_6_80 VGND VGND VPWR VPWR sky130_fd_sc_hd__decap_3
XFILLER_17_166 VGND VGND VPWR VPWR sky130_fd_sc_hd__fill_1
XFILLER_26_166 VGND VGND VPWR VPWR sky130_fd_sc_hd__fill_1
XTAP_TAPCELL_ROW_19_106 VGND VPWR sky130_fd_sc_hd__tapvpwrvgnd_1
Xrebuffer131 _353_/A VGND VGND VPWR VPWR _354_/B sky130_fd_sc_hd__buf_2
X_388_ _431_/A _388_/B VGND VGND VPWR VPWR _389_/B sky130_fd_sc_hd__xor2_4
XFILLER_14_103 VGND VGND VPWR VPWR sky130_fd_sc_hd__fill_2
XTAP_TAPCELL_ROW_24_120 VGND VPWR sky130_fd_sc_hd__tapvpwrvgnd_1
Xinput19 A[26] VGND VGND VPWR VPWR _294_/A sky130_fd_sc_hd__clkdlybuf4s25_1
X_311_ _311_/A _311_/B VGND VGND VPWR VPWR _311_/X sky130_fd_sc_hd__and2_2
X_242_ _372_/A _242_/B VGND VGND VPWR VPWR _245_/B sky130_fd_sc_hd__xor2_2
XFILLER_20_106 VGND VGND VPWR VPWR sky130_fd_sc_hd__decap_3
XFILLER_22_35 VGND VGND VPWR VPWR sky130_fd_sc_hd__decap_3
XTAP_TAPCELL_ROW_21_112 VGND VPWR sky130_fd_sc_hd__tapvpwrvgnd_1
XFILLER_6_165 VGND VGND VPWR VPWR sky130_fd_sc_hd__fill_2
XFILLER_8_37 VGND VGND VPWR VPWR sky130_fd_sc_hd__decap_3
XTAP_TAPCELL_ROW_12_90 VGND VPWR sky130_fd_sc_hd__tapvpwrvgnd_1
X_225_ _441_/A _225_/B VGND VGND VPWR VPWR _227_/C sky130_fd_sc_hd__nand2_2
XTAP_TAPCELL_ROW_8_80 VGND VPWR sky130_fd_sc_hd__tapvpwrvgnd_1
XFILLER_17_57 VGND VGND VPWR VPWR sky130_fd_sc_hd__decap_3
XFILLER_17_68 VGND VGND VPWR VPWR sky130_fd_sc_hd__decap_3
XFILLER_3_113 VGND VGND VPWR VPWR sky130_fd_sc_hd__fill_2
XPHY_EDGE_ROW_9_Left_37 VGND VGND VPWR VPWR sky130_fd_sc_hd__decap_3
X_208_ _447_/X _448_/Y VGND VGND VPWR VPWR _368_/A sky130_fd_sc_hd__or2_2
XFILLER_14_14 VGND VGND VPWR VPWR sky130_fd_sc_hd__fill_1
XFILLER_9_3 VGND VGND VPWR VPWR sky130_fd_sc_hd__decap_3
XTAP_TAPCELL_ROW_19_107 VGND VPWR sky130_fd_sc_hd__tapvpwrvgnd_1
Xrebuffer110 _411_/B VGND VGND VPWR VPWR _408_/A sky130_fd_sc_hd__buf_4
Xrebuffer121 fanout104/X VGND VGND VPWR VPWR _272_/A sky130_fd_sc_hd__buf_2
Xrebuffer132 input65/X VGND VGND VPWR VPWR _415_/A sky130_fd_sc_hd__buf_2
X_387_ _400_/A _400_/B VGND VGND VPWR VPWR _387_/Y sky130_fd_sc_hd__nand2_2
XFILLER_11_26 VGND VGND VPWR VPWR sky130_fd_sc_hd__decap_3
X_310_ _281_/A _290_/A _298_/A _306_/A _311_/B VGND VGND VPWR VPWR _310_/X sky130_fd_sc_hd__o41a_2
XFILLER_20_118 VGND VGND VPWR VPWR sky130_fd_sc_hd__decap_3
X_439_ _439_/A _439_/B VGND VGND VPWR VPWR _439_/X sky130_fd_sc_hd__or2_4
X_241_ _247_/A _241_/B VGND VGND VPWR VPWR _241_/X sky130_fd_sc_hd__xor2_2
XFILLER_22_69 VGND VGND VPWR VPWR sky130_fd_sc_hd__decap_3
XFILLER_3_60 VGND VGND VPWR VPWR sky130_fd_sc_hd__fill_1
XFILLER_10_162 VGND VGND VPWR VPWR sky130_fd_sc_hd__decap_3
XFILLER_12_91 VGND VGND VPWR VPWR sky130_fd_sc_hd__fill_2
XFILLER_6_111 VGND VGND VPWR VPWR sky130_fd_sc_hd__decap_3
XFILLER_8_27 VGND VGND VPWR VPWR sky130_fd_sc_hd__fill_1
XFILLER_8_49 VGND VGND VPWR VPWR sky130_fd_sc_hd__decap_3
X_224_ _441_/A _225_/B VGND VGND VPWR VPWR _227_/B sky130_fd_sc_hd__or2_2
XPHY_EDGE_ROW_25_Left_53 VGND VGND VPWR VPWR sky130_fd_sc_hd__decap_3
XFILLER_17_47 VGND VGND VPWR VPWR sky130_fd_sc_hd__decap_3
XFILLER_24_3 VGND VGND VPWR VPWR sky130_fd_sc_hd__fill_1
XFILLER_14_48 VGND VGND VPWR VPWR sky130_fd_sc_hd__decap_3
XPHY_EDGE_ROW_12_Left_40 VGND VGND VPWR VPWR sky130_fd_sc_hd__decap_3
XPHY_EDGE_ROW_7_Right_7 VGND VGND VPWR VPWR sky130_fd_sc_hd__decap_3
XTAP_TAPCELL_ROW_5_71 VGND VPWR sky130_fd_sc_hd__tapvpwrvgnd_1
XFILLER_6_93 VGND VGND VPWR VPWR sky130_fd_sc_hd__decap_3
Xrebuffer111 _411_/B VGND VGND VPWR VPWR _378_/A sky130_fd_sc_hd__buf_6
Xrebuffer133 _416_/B VGND VGND VPWR VPWR _424_/B sky130_fd_sc_hd__buf_4
XFILLER_15_80 VGND VGND VPWR VPWR sky130_fd_sc_hd__decap_3
XFILLER_17_113 VGND VGND VPWR VPWR sky130_fd_sc_hd__decap_3
XFILLER_2_29 VGND VGND VPWR VPWR sky130_fd_sc_hd__fill_1
XTAP_TAPCELL_ROW_27_130 VGND VPWR sky130_fd_sc_hd__tapvpwrvgnd_1
Xoutput90 _336_/X VGND VGND VPWR VPWR S[31] sky130_fd_sc_hd__buf_6
X_386_ _386_/A _386_/B VGND VGND VPWR VPWR _400_/B sky130_fd_sc_hd__xor2_2
XFILLER_11_38 VGND VGND VPWR VPWR sky130_fd_sc_hd__decap_3
X_240_ _229_/A _247_/B _239_/Y _228_/A VGND VGND VPWR VPWR _241_/B sky130_fd_sc_hd__o22a_2
XFILLER_9_164 VGND VGND VPWR VPWR sky130_fd_sc_hd__decap_3
X_438_ _437_/B _437_/C _437_/A VGND VGND VPWR VPWR _439_/B sky130_fd_sc_hd__a21oi_2
X_369_ _336_/B _336_/A _334_/B VGND VGND VPWR VPWR _369_/Y sky130_fd_sc_hd__o21ai_2
X_223_ _238_/B _223_/B VGND VGND VPWR VPWR _223_/Y sky130_fd_sc_hd__xnor2_2
XFILLER_12_70 VGND VGND VPWR VPWR sky130_fd_sc_hd__decap_3
XFILLER_0_95 VGND VGND VPWR VPWR sky130_fd_sc_hd__fill_2
XFILLER_17_3 VGND VGND VPWR VPWR sky130_fd_sc_hd__decap_3
XFILLER_9_82 VGND VGND VPWR VPWR sky130_fd_sc_hd__fill_1
XFILLER_18_91 VGND VGND VPWR VPWR sky130_fd_sc_hd__decap_3
XTAP_TAPCELL_ROW_5_72 VGND VPWR sky130_fd_sc_hd__tapvpwrvgnd_1
XFILLER_6_50 VGND VGND VPWR VPWR sky130_fd_sc_hd__decap_3
XFILLER_6_83 VGND VGND VPWR VPWR sky130_fd_sc_hd__fill_1
Xrebuffer112 _428_/C VGND VGND VPWR VPWR _340_/B sky130_fd_sc_hd__buf_6
XFILLER_15_92 VGND VGND VPWR VPWR sky130_fd_sc_hd__decap_3
XFILLER_17_136 VGND VGND VPWR VPWR sky130_fd_sc_hd__fill_1
X_385_ _401_/A _401_/B VGND VGND VPWR VPWR _398_/A sky130_fd_sc_hd__and2b_2
Xoutput80 _262_/Y VGND VGND VPWR VPWR S[22] sky130_fd_sc_hd__buf_4
Xoutput91 _343_/Y VGND VGND VPWR VPWR S[3] sky130_fd_sc_hd__buf_6
XFILLER_20_109 VGND VGND VPWR VPWR sky130_fd_sc_hd__decap_3
XFILLER_9_110 VGND VGND VPWR VPWR sky130_fd_sc_hd__fill_2
X_437_ _437_/A _437_/B _437_/C VGND VGND VPWR VPWR _439_/A sky130_fd_sc_hd__and3_2
X_368_ _368_/A _368_/B VGND VGND VPWR VPWR _368_/Y sky130_fd_sc_hd__xnor2_2
X_299_ _446_/A _300_/B VGND VGND VPWR VPWR _301_/B sky130_fd_sc_hd__or2_2
XFILLER_11_109 VGND VGND VPWR VPWR sky130_fd_sc_hd__decap_3
XFILLER_22_38 VGND VGND VPWR VPWR sky130_fd_sc_hd__fill_1
XFILLER_12_82 VGND VGND VPWR VPWR sky130_fd_sc_hd__fill_2
XFILLER_6_102 VGND VGND VPWR VPWR sky130_fd_sc_hd__decap_3
X_222_ _229_/A _238_/A _218_/A VGND VGND VPWR VPWR _223_/B sky130_fd_sc_hd__o21ai_4
XFILLER_23_70 VGND VGND VPWR VPWR sky130_fd_sc_hd__decap_3
Xload_slew100 _372_/A VGND VGND VPWR VPWR _441_/A sky130_fd_sc_hd__buf_6
XFILLER_20_82 VGND VGND VPWR VPWR sky130_fd_sc_hd__fill_2
XFILLER_9_6 VGND VGND VPWR VPWR sky130_fd_sc_hd__fill_2
Xrebuffer113 _423_/A VGND VGND VPWR VPWR _419_/A2 sky130_fd_sc_hd__buf_2
Xrebuffer124 _344_/X VGND VGND VPWR VPWR _345_/B sky130_fd_sc_hd__buf_4
X_384_ _401_/B _401_/A VGND VGND VPWR VPWR _384_/Y sky130_fd_sc_hd__nand2b_2
XFILLER_11_29 VGND VGND VPWR VPWR sky130_fd_sc_hd__decap_3
XTAP_TAPCELL_ROW_2_63 VGND VPWR sky130_fd_sc_hd__tapvpwrvgnd_1
Xoutput70 _363_/Y VGND VGND VPWR VPWR S[13] sky130_fd_sc_hd__buf_6
Xoutput81 _271_/Y VGND VGND VPWR VPWR S[23] sky130_fd_sc_hd__buf_6
Xoutput92 _345_/X VGND VGND VPWR VPWR S[4] sky130_fd_sc_hd__buf_6
X_436_ _436_/A _436_/B VGND VGND VPWR VPWR _437_/C sky130_fd_sc_hd__nand2_2
X_367_ _444_/X _365_/B _212_/X VGND VGND VPWR VPWR _368_/B sky130_fd_sc_hd__o21ai_4
X_298_ _298_/A _298_/B VGND VGND VPWR VPWR _298_/Y sky130_fd_sc_hd__xnor2_2
Xfanout101 _446_/A VGND VGND VPWR VPWR _331_/A sky130_fd_sc_hd__clkbuf_4
XFILLER_10_165 VGND VGND VPWR VPWR sky130_fd_sc_hd__fill_2
XFILLER_12_50 VGND VGND VPWR VPWR sky130_fd_sc_hd__decap_3
X_221_ _221_/A _221_/B VGND VGND VPWR VPWR _238_/B sky130_fd_sc_hd__xnor2_2
X_419_ _423_/B _419_/A2 _417_/X _419_/C1 VGND VGND VPWR VPWR _419_/Y sky130_fd_sc_hd__a211oi_2
XFILLER_9_95 VGND VGND VPWR VPWR sky130_fd_sc_hd__decap_3
XFILLER_18_82 VGND VGND VPWR VPWR sky130_fd_sc_hd__fill_2
XFILLER_22_3 VGND VGND VPWR VPWR sky130_fd_sc_hd__decap_3
XFILLER_20_50 VGND VGND VPWR VPWR sky130_fd_sc_hd__decap_3
XFILLER_20_72 VGND VGND VPWR VPWR sky130_fd_sc_hd__decap_3
XFILLER_6_41 VGND VGND VPWR VPWR sky130_fd_sc_hd__decap_3
XFILLER_6_96 VGND VGND VPWR VPWR sky130_fd_sc_hd__decap_3
XPHY_EDGE_ROW_16_Left_44 VGND VGND VPWR VPWR sky130_fd_sc_hd__decap_3
XFILLER_17_116 VGND VGND VPWR VPWR sky130_fd_sc_hd__fill_1
Xrebuffer114 _382_/C VGND VGND VPWR VPWR _356_/A sky130_fd_sc_hd__buf_2
Xrebuffer125 _358_/B VGND VGND VPWR VPWR _359_/A2 sky130_fd_sc_hd__buf_6
X_383_ _431_/A _383_/B VGND VGND VPWR VPWR _401_/B sky130_fd_sc_hd__xnor2_2
XFILLER_15_83 VGND VGND VPWR VPWR sky130_fd_sc_hd__decap_3
XTAP_TAPCELL_ROW_2_64 VGND VPWR sky130_fd_sc_hd__tapvpwrvgnd_1
Xoutput71 _366_/Y VGND VGND VPWR VPWR S[14] sky130_fd_sc_hd__buf_6
Xoutput82 _283_/X VGND VGND VPWR VPWR S[24] sky130_fd_sc_hd__clkbuf_4
Xoutput93 _347_/X VGND VGND VPWR VPWR S[5] sky130_fd_sc_hd__buf_6
XPHY_EDGE_ROW_1_Left_29 VGND VGND VPWR VPWR sky130_fd_sc_hd__decap_3
XFILLER_9_101 VGND VGND VPWR VPWR sky130_fd_sc_hd__decap_3
X_435_ _436_/A _436_/B VGND VGND VPWR VPWR _437_/B sky130_fd_sc_hd__or2_2
X_366_ _444_/X _366_/B VGND VGND VPWR VPWR _366_/Y sky130_fd_sc_hd__xnor2_2
X_297_ _289_/B _290_/A _296_/X VGND VGND VPWR VPWR _298_/B sky130_fd_sc_hd__o21ai_4
XFILLER_3_86 VGND VGND VPWR VPWR sky130_fd_sc_hd__fill_2
XFILLER_12_73 VGND VGND VPWR VPWR sky130_fd_sc_hd__decap_3
X_220_ _441_/A _220_/B VGND VGND VPWR VPWR _221_/B sky130_fd_sc_hd__xor2_2
X_418_ _423_/B _419_/A2 _417_/X VGND VGND VPWR VPWR _418_/Y sky130_fd_sc_hd__a21oi_2
X_349_ _402_/A _349_/B VGND VGND VPWR VPWR _349_/Y sky130_fd_sc_hd__xnor2_2
XFILLER_17_6 VGND VGND VPWR VPWR sky130_fd_sc_hd__decap_3
XFILLER_23_50 VGND VGND VPWR VPWR sky130_fd_sc_hd__decap_3
XPHY_EDGE_ROW_4_Left_32 VGND VGND VPWR VPWR sky130_fd_sc_hd__decap_3
XFILLER_18_94 VGND VGND VPWR VPWR sky130_fd_sc_hd__fill_1
XFILLER_15_3 VGND VGND VPWR VPWR sky130_fd_sc_hd__fill_2
Xload_slew102 _331_/A VGND VGND VPWR VPWR _323_/A sky130_fd_sc_hd__buf_6
XFILLER_6_53 VGND VGND VPWR VPWR sky130_fd_sc_hd__decap_3
XFILLER_17_106 VGND VGND VPWR VPWR sky130_fd_sc_hd__decap_3
XFILLER_26_106 VGND VGND VPWR VPWR sky130_fd_sc_hd__fill_1
Xrebuffer115 _381_/A VGND VGND VPWR VPWR _380_/B sky130_fd_sc_hd__buf_2
Xrebuffer126 _428_/A VGND VGND VPWR VPWR _343_/A sky130_fd_sc_hd__buf_2
XFILLER_15_95 VGND VGND VPWR VPWR sky130_fd_sc_hd__decap_3
XTAP_TAPCELL_ROW_2_65 VGND VPWR sky130_fd_sc_hd__tapvpwrvgnd_1
Xoutput72 _368_/Y VGND VGND VPWR VPWR S[15] sky130_fd_sc_hd__buf_6
Xoutput83 _290_/Y VGND VGND VPWR VPWR S[25] sky130_fd_sc_hd__buf_6
Xoutput94 _349_/Y VGND VGND VPWR VPWR S[6] sky130_fd_sc_hd__buf_6
X_382_ _382_/A _382_/B _382_/C _382_/D VGND VGND VPWR VPWR _382_/X sky130_fd_sc_hd__or4_4
XFILLER_22_120 VGND VGND VPWR VPWR sky130_fd_sc_hd__decap_3
XFILLER_26_72 VGND VGND VPWR VPWR sky130_fd_sc_hd__decap_3
XFILLER_9_113 VGND VGND VPWR VPWR sky130_fd_sc_hd__decap_3
X_434_ _434_/A _434_/B VGND VGND VPWR VPWR _434_/Y sky130_fd_sc_hd__nand2_2
X_365_ _365_/A _365_/B VGND VGND VPWR VPWR _366_/B sky130_fd_sc_hd__nand2_2
X_296_ _289_/A _288_/B _288_/A VGND VGND VPWR VPWR _296_/X sky130_fd_sc_hd__a21bo_2
XFILLER_10_123 VGND VGND VPWR VPWR sky130_fd_sc_hd__fill_1
XFILLER_12_41 VGND VGND VPWR VPWR sky130_fd_sc_hd__decap_3
XFILLER_12_85 VGND VGND VPWR VPWR sky130_fd_sc_hd__fill_2
XFILLER_6_105 VGND VGND VPWR VPWR sky130_fd_sc_hd__decap_3
XFILLER_6_127 VGND VGND VPWR VPWR sky130_fd_sc_hd__decap_3
Xfanout103 input65/X VGND VGND VPWR VPWR _446_/A sky130_fd_sc_hd__buf_6
XPHY_EDGE_ROW_16_Right_16 VGND VGND VPWR VPWR sky130_fd_sc_hd__decap_3
XPHY_EDGE_ROW_25_Right_25 VGND VGND VPWR VPWR sky130_fd_sc_hd__decap_3
X_417_ _423_/B _419_/A2 _424_/B _424_/A VGND VGND VPWR VPWR _417_/X sky130_fd_sc_hd__o211a_2
X_348_ _392_/Y _347_/B _391_/Y VGND VGND VPWR VPWR _349_/B sky130_fd_sc_hd__o21ai_4
X_279_ _267_/A _279_/B _279_/C VGND VGND VPWR VPWR _311_/A sky130_fd_sc_hd__and3b_2
XFILLER_0_11 VGND VGND VPWR VPWR sky130_fd_sc_hd__fill_1
XFILLER_23_73 VGND VGND VPWR VPWR sky130_fd_sc_hd__decap_3
XPHY_EDGE_ROW_2_Right_2 VGND VGND VPWR VPWR sky130_fd_sc_hd__decap_3
XFILLER_20_41 VGND VGND VPWR VPWR sky130_fd_sc_hd__decap_3
XFILLER_20_85 VGND VGND VPWR VPWR sky130_fd_sc_hd__decap_3
XFILLER_6_32 VGND VGND VPWR VPWR sky130_fd_sc_hd__decap_3
XTAP_TAPCELL_ROW_15_96 VGND VPWR sky130_fd_sc_hd__tapvpwrvgnd_1
Xrebuffer116 _381_/A VGND VGND VPWR VPWR _379_/B sky130_fd_sc_hd__buf_2
Xrebuffer127 _425_/A VGND VGND VPWR VPWR _339_/A sky130_fd_sc_hd__buf_2
Xoutput73 _219_/X VGND VGND VPWR VPWR S[16] sky130_fd_sc_hd__clkbuf_2
Xoutput84 _298_/Y VGND VGND VPWR VPWR S[26] sky130_fd_sc_hd__buf_6
Xoutput95 _351_/Y VGND VGND VPWR VPWR S[7] sky130_fd_sc_hd__buf_6
X_381_ _381_/A _381_/B VGND VGND VPWR VPWR _382_/C sky130_fd_sc_hd__xnor2_4
X_433_ _433_/A _433_/B VGND VGND VPWR VPWR _434_/B sky130_fd_sc_hd__or2_2
X_364_ _439_/X _434_/Y _430_/X VGND VGND VPWR VPWR _365_/B sky130_fd_sc_hd__or3_4
X_295_ _293_/Y _295_/B VGND VGND VPWR VPWR _298_/A sky130_fd_sc_hd__nand2b_2
Xfanout104 fanout106/X VGND VGND VPWR VPWR fanout104/X sky130_fd_sc_hd__buf_6
XFILLER_12_53 VGND VGND VPWR VPWR sky130_fd_sc_hd__decap_3
X_416_ _424_/A _416_/B VGND VGND VPWR VPWR _425_/B sky130_fd_sc_hd__and2_4
X_347_ _402_/B _347_/B VGND VGND VPWR VPWR _347_/X sky130_fd_sc_hd__xor2_2
X_278_ _267_/B _278_/B VGND VGND VPWR VPWR _279_/C sky130_fd_sc_hd__nand2b_2
XFILLER_9_76 VGND VGND VPWR VPWR sky130_fd_sc_hd__decap_3
XFILLER_9_98 VGND VGND VPWR VPWR sky130_fd_sc_hd__decap_3
XFILLER_18_52 VGND VGND VPWR VPWR sky130_fd_sc_hd__decap_3
XFILLER_18_85 VGND VGND VPWR VPWR sky130_fd_sc_hd__decap_3
XFILLER_22_6 VGND VGND VPWR VPWR sky130_fd_sc_hd__fill_1
XFILLER_20_53 VGND VGND VPWR VPWR sky130_fd_sc_hd__decap_3
XFILLER_6_44 VGND VGND VPWR VPWR sky130_fd_sc_hd__decap_3
XFILLER_6_99 VGND VGND VPWR VPWR sky130_fd_sc_hd__decap_3
Xrebuffer117 fanout106/X VGND VGND VPWR VPWR _436_/A sky130_fd_sc_hd__buf_2
Xrebuffer128 _428_/B VGND VGND VPWR VPWR _341_/A sky130_fd_sc_hd__buf_2
XFILLER_15_86 VGND VGND VPWR VPWR sky130_fd_sc_hd__decap_3
XTAP_TAPCELL_ROW_15_97 VGND VPWR sky130_fd_sc_hd__tapvpwrvgnd_1
X_380_ _381_/B _380_/B VGND VGND VPWR VPWR _380_/Y sky130_fd_sc_hd__nor2_2
XFILLER_16_141 VGND VGND VPWR VPWR sky130_fd_sc_hd__fill_2
XTAP_TAPCELL_ROW_18_103 VGND VPWR sky130_fd_sc_hd__tapvpwrvgnd_1
Xoutput74 _223_/Y VGND VGND VPWR VPWR S[17] sky130_fd_sc_hd__buf_6
Xoutput85 _306_/X VGND VGND VPWR VPWR S[27] sky130_fd_sc_hd__buf_4
Xoutput96 _354_/X VGND VGND VPWR VPWR S[8] sky130_fd_sc_hd__buf_6
.ends
