* NGSPICE file created from addsub32.ext - technology: sky130A

* Black-box entry subcircuit for sky130_fd_sc_hd__decap_3 abstract view
.subckt sky130_fd_sc_hd__decap_3 VGND VNB VPB VPWR
.ends

* Black-box entry subcircuit for sky130_fd_sc_hd__fill_1 abstract view
.subckt sky130_fd_sc_hd__fill_1 VGND VNB VPB VPWR
.ends

* Black-box entry subcircuit for sky130_fd_sc_hd__o21bai_4 abstract view
.subckt sky130_fd_sc_hd__o21bai_4 A1 A2 B1_N VGND VNB VPB VPWR Y
.ends

* Black-box entry subcircuit for sky130_fd_sc_hd__a21bo_2 abstract view
.subckt sky130_fd_sc_hd__a21bo_2 A1 A2 B1_N VGND VNB VPB VPWR X
.ends

* Black-box entry subcircuit for sky130_fd_sc_hd__tapvpwrvgnd_1 abstract view
.subckt sky130_fd_sc_hd__tapvpwrvgnd_1 VGND VPWR
.ends

* Black-box entry subcircuit for sky130_fd_sc_hd__nand2b_2 abstract view
.subckt sky130_fd_sc_hd__nand2b_2 A_N B VGND VNB VPB VPWR Y
.ends

* Black-box entry subcircuit for sky130_fd_sc_hd__buf_8 abstract view
.subckt sky130_fd_sc_hd__buf_8 A VGND VNB VPB VPWR X
.ends

* Black-box entry subcircuit for sky130_fd_sc_hd__clkbuf_2 abstract view
.subckt sky130_fd_sc_hd__clkbuf_2 A VGND VNB VPB VPWR X
.ends

* Black-box entry subcircuit for sky130_fd_sc_hd__nand3_4 abstract view
.subckt sky130_fd_sc_hd__nand3_4 A B C VGND VNB VPB VPWR Y
.ends

* Black-box entry subcircuit for sky130_fd_sc_hd__fill_2 abstract view
.subckt sky130_fd_sc_hd__fill_2 VGND VNB VPB VPWR
.ends

* Black-box entry subcircuit for sky130_fd_sc_hd__o21bai_2 abstract view
.subckt sky130_fd_sc_hd__o21bai_2 A1 A2 B1_N VGND VNB VPB VPWR Y
.ends

* Black-box entry subcircuit for sky130_fd_sc_hd__o21ba_2 abstract view
.subckt sky130_fd_sc_hd__o21ba_2 A1 A2 B1_N VGND VNB VPB VPWR X
.ends

* Black-box entry subcircuit for sky130_fd_sc_hd__and2_4 abstract view
.subckt sky130_fd_sc_hd__and2_4 A B VGND VNB VPB VPWR X
.ends

* Black-box entry subcircuit for sky130_fd_sc_hd__buf_2 abstract view
.subckt sky130_fd_sc_hd__buf_2 A VGND VNB VPB VPWR X
.ends

* Black-box entry subcircuit for sky130_fd_sc_hd__clkbuf_4 abstract view
.subckt sky130_fd_sc_hd__clkbuf_4 A VGND VNB VPB VPWR X
.ends

* Black-box entry subcircuit for sky130_fd_sc_hd__nand2_4 abstract view
.subckt sky130_fd_sc_hd__nand2_4 A B VGND VNB VPB VPWR Y
.ends

* Black-box entry subcircuit for sky130_fd_sc_hd__buf_6 abstract view
.subckt sky130_fd_sc_hd__buf_6 A VGND VNB VPB VPWR X
.ends

* Black-box entry subcircuit for sky130_fd_sc_hd__nand2_8 abstract view
.subckt sky130_fd_sc_hd__nand2_8 A B VGND VNB VPB VPWR Y
.ends

* Black-box entry subcircuit for sky130_fd_sc_hd__a21o_2 abstract view
.subckt sky130_fd_sc_hd__a21o_2 A1 A2 B1 VGND VNB VPB VPWR X
.ends

* Black-box entry subcircuit for sky130_fd_sc_hd__nand2_2 abstract view
.subckt sky130_fd_sc_hd__nand2_2 A B VGND VNB VPB VPWR Y
.ends

* Black-box entry subcircuit for sky130_fd_sc_hd__xnor2_2 abstract view
.subckt sky130_fd_sc_hd__xnor2_2 A B VGND VNB VPB VPWR Y
.ends

* Black-box entry subcircuit for sky130_fd_sc_hd__a21oi_4 abstract view
.subckt sky130_fd_sc_hd__a21oi_4 A1 A2 B1 VGND VNB VPB VPWR Y
.ends

* Black-box entry subcircuit for sky130_fd_sc_hd__or3b_4 abstract view
.subckt sky130_fd_sc_hd__or3b_4 A B C_N VGND VNB VPB VPWR X
.ends

* Black-box entry subcircuit for sky130_fd_sc_hd__or3b_2 abstract view
.subckt sky130_fd_sc_hd__or3b_2 A B C_N VGND VNB VPB VPWR X
.ends

* Black-box entry subcircuit for sky130_fd_sc_hd__o211ai_2 abstract view
.subckt sky130_fd_sc_hd__o211ai_2 A1 A2 B1 C1 VGND VNB VPB VPWR Y
.ends

* Black-box entry subcircuit for sky130_fd_sc_hd__o21a_4 abstract view
.subckt sky130_fd_sc_hd__o21a_4 A1 A2 B1 VGND VNB VPB VPWR X
.ends

* Black-box entry subcircuit for sky130_fd_sc_hd__o21ai_2 abstract view
.subckt sky130_fd_sc_hd__o21ai_2 A1 A2 B1 VGND VNB VPB VPWR Y
.ends

* Black-box entry subcircuit for sky130_fd_sc_hd__and2_2 abstract view
.subckt sky130_fd_sc_hd__and2_2 A B VGND VNB VPB VPWR X
.ends

* Black-box entry subcircuit for sky130_fd_sc_hd__a22oi_2 abstract view
.subckt sky130_fd_sc_hd__a22oi_2 A1 A2 B1 B2 VGND VNB VPB VPWR Y
.ends

* Black-box entry subcircuit for sky130_fd_sc_hd__a31o_2 abstract view
.subckt sky130_fd_sc_hd__a31o_2 A1 A2 A3 B1 VGND VNB VPB VPWR X
.ends

* Black-box entry subcircuit for sky130_fd_sc_hd__o21ai_4 abstract view
.subckt sky130_fd_sc_hd__o21ai_4 A1 A2 B1 VGND VNB VPB VPWR Y
.ends

* Black-box entry subcircuit for sky130_fd_sc_hd__buf_4 abstract view
.subckt sky130_fd_sc_hd__buf_4 A VGND VNB VPB VPWR X
.ends

* Black-box entry subcircuit for sky130_fd_sc_hd__clkdlybuf4s25_1 abstract view
.subckt sky130_fd_sc_hd__clkdlybuf4s25_1 A VGND VNB VPB VPWR X
.ends

* Black-box entry subcircuit for sky130_fd_sc_hd__nand3b_2 abstract view
.subckt sky130_fd_sc_hd__nand3b_2 A_N B C VGND VNB VPB VPWR Y
.ends

* Black-box entry subcircuit for sky130_fd_sc_hd__o2111ai_4 abstract view
.subckt sky130_fd_sc_hd__o2111ai_4 A1 A2 B1 C1 D1 VGND VNB VPB VPWR Y
.ends

* Black-box entry subcircuit for sky130_fd_sc_hd__nor2_2 abstract view
.subckt sky130_fd_sc_hd__nor2_2 A B VGND VNB VPB VPWR Y
.ends

* Black-box entry subcircuit for sky130_fd_sc_hd__dlymetal6s4s_1 abstract view
.subckt sky130_fd_sc_hd__dlymetal6s4s_1 A VGND VNB VPB VPWR X
.ends

* Black-box entry subcircuit for sky130_fd_sc_hd__o221ai_4 abstract view
.subckt sky130_fd_sc_hd__o221ai_4 A1 A2 B1 B2 C1 VGND VNB VPB VPWR Y
.ends

* Black-box entry subcircuit for sky130_fd_sc_hd__a22o_2 abstract view
.subckt sky130_fd_sc_hd__a22o_2 A1 A2 B1 B2 VGND VNB VPB VPWR X
.ends

* Black-box entry subcircuit for sky130_fd_sc_hd__nor2b_4 abstract view
.subckt sky130_fd_sc_hd__nor2b_4 A B_N VGND VNB VPB VPWR Y
.ends

* Black-box entry subcircuit for sky130_fd_sc_hd__o22a_4 abstract view
.subckt sky130_fd_sc_hd__o22a_4 A1 A2 B1 B2 VGND VNB VPB VPWR X
.ends

* Black-box entry subcircuit for sky130_fd_sc_hd__nor2_4 abstract view
.subckt sky130_fd_sc_hd__nor2_4 A B VGND VNB VPB VPWR Y
.ends

* Black-box entry subcircuit for sky130_fd_sc_hd__o211a_2 abstract view
.subckt sky130_fd_sc_hd__o211a_2 A1 A2 B1 C1 VGND VNB VPB VPWR X
.ends

* Black-box entry subcircuit for sky130_fd_sc_hd__xor2_2 abstract view
.subckt sky130_fd_sc_hd__xor2_2 A B VGND VNB VPB VPWR X
.ends

* Black-box entry subcircuit for sky130_fd_sc_hd__o2bb2ai_2 abstract view
.subckt sky130_fd_sc_hd__o2bb2ai_2 A1_N A2_N B1 B2 VGND VNB VPB VPWR Y
.ends

* Black-box entry subcircuit for sky130_fd_sc_hd__nand4_4 abstract view
.subckt sky130_fd_sc_hd__nand4_4 A B C D VGND VNB VPB VPWR Y
.ends

* Black-box entry subcircuit for sky130_fd_sc_hd__o21a_2 abstract view
.subckt sky130_fd_sc_hd__o21a_2 A1 A2 B1 VGND VNB VPB VPWR X
.ends

* Black-box entry subcircuit for sky130_fd_sc_hd__a21oi_2 abstract view
.subckt sky130_fd_sc_hd__a21oi_2 A1 A2 B1 VGND VNB VPB VPWR Y
.ends

* Black-box entry subcircuit for sky130_fd_sc_hd__inv_2 abstract view
.subckt sky130_fd_sc_hd__inv_2 A VGND VNB VPB VPWR Y
.ends

* Black-box entry subcircuit for sky130_fd_sc_hd__nand4_2 abstract view
.subckt sky130_fd_sc_hd__nand4_2 A B C D VGND VNB VPB VPWR Y
.ends

* Black-box entry subcircuit for sky130_fd_sc_hd__nand3_2 abstract view
.subckt sky130_fd_sc_hd__nand3_2 A B C VGND VNB VPB VPWR Y
.ends

* Black-box entry subcircuit for sky130_fd_sc_hd__o22a_2 abstract view
.subckt sky130_fd_sc_hd__o22a_2 A1 A2 B1 B2 VGND VNB VPB VPWR X
.ends

* Black-box entry subcircuit for sky130_fd_sc_hd__a21boi_2 abstract view
.subckt sky130_fd_sc_hd__a21boi_2 A1 A2 B1_N VGND VNB VPB VPWR Y
.ends

* Black-box entry subcircuit for sky130_fd_sc_hd__nand3b_4 abstract view
.subckt sky130_fd_sc_hd__nand3b_4 A_N B C VGND VNB VPB VPWR Y
.ends

* Black-box entry subcircuit for sky130_fd_sc_hd__nand2b_4 abstract view
.subckt sky130_fd_sc_hd__nand2b_4 A_N B VGND VNB VPB VPWR Y
.ends

* Black-box entry subcircuit for sky130_fd_sc_hd__nor4_4 abstract view
.subckt sky130_fd_sc_hd__nor4_4 A B C D VGND VNB VPB VPWR Y
.ends

* Black-box entry subcircuit for sky130_fd_sc_hd__a31oi_2 abstract view
.subckt sky130_fd_sc_hd__a31oi_2 A1 A2 A3 B1 VGND VNB VPB VPWR Y
.ends

* Black-box entry subcircuit for sky130_fd_sc_hd__nand4b_2 abstract view
.subckt sky130_fd_sc_hd__nand4b_2 A_N B C D VGND VNB VPB VPWR Y
.ends

* Black-box entry subcircuit for sky130_fd_sc_hd__or2_4 abstract view
.subckt sky130_fd_sc_hd__or2_4 A B VGND VNB VPB VPWR X
.ends

* Black-box entry subcircuit for sky130_fd_sc_hd__a211o_4 abstract view
.subckt sky130_fd_sc_hd__a211o_4 A1 A2 B1 C1 VGND VNB VPB VPWR X
.ends

* Black-box entry subcircuit for sky130_fd_sc_hd__nand4b_4 abstract view
.subckt sky130_fd_sc_hd__nand4b_4 A_N B C D VGND VNB VPB VPWR Y
.ends

* Black-box entry subcircuit for sky130_fd_sc_hd__a22oi_4 abstract view
.subckt sky130_fd_sc_hd__a22oi_4 A1 A2 B1 B2 VGND VNB VPB VPWR Y
.ends

* Black-box entry subcircuit for sky130_fd_sc_hd__a41o_2 abstract view
.subckt sky130_fd_sc_hd__a41o_2 A1 A2 A3 A4 B1 VGND VNB VPB VPWR X
.ends

* Black-box entry subcircuit for sky130_fd_sc_hd__a31oi_4 abstract view
.subckt sky130_fd_sc_hd__a31oi_4 A1 A2 A3 B1 VGND VNB VPB VPWR Y
.ends

* Black-box entry subcircuit for sky130_fd_sc_hd__and4_4 abstract view
.subckt sky130_fd_sc_hd__and4_4 A B C D VGND VNB VPB VPWR X
.ends

* Black-box entry subcircuit for sky130_fd_sc_hd__and3_2 abstract view
.subckt sky130_fd_sc_hd__and3_2 A B C VGND VNB VPB VPWR X
.ends

* Black-box entry subcircuit for sky130_fd_sc_hd__a211oi_4 abstract view
.subckt sky130_fd_sc_hd__a211oi_4 A1 A2 B1 C1 VGND VNB VPB VPWR Y
.ends

* Black-box entry subcircuit for sky130_fd_sc_hd__a2bb2oi_2 abstract view
.subckt sky130_fd_sc_hd__a2bb2oi_2 A1_N A2_N B1 B2 VGND VNB VPB VPWR Y
.ends

* Black-box entry subcircuit for sky130_fd_sc_hd__o2111a_2 abstract view
.subckt sky130_fd_sc_hd__o2111a_2 A1 A2 B1 C1 D1 VGND VNB VPB VPWR X
.ends

* Black-box entry subcircuit for sky130_fd_sc_hd__o31a_2 abstract view
.subckt sky130_fd_sc_hd__o31a_2 A1 A2 A3 B1 VGND VNB VPB VPWR X
.ends

* Black-box entry subcircuit for sky130_fd_sc_hd__and4_2 abstract view
.subckt sky130_fd_sc_hd__and4_2 A B C D VGND VNB VPB VPWR X
.ends

* Black-box entry subcircuit for sky130_fd_sc_hd__o22ai_4 abstract view
.subckt sky130_fd_sc_hd__o22ai_4 A1 A2 B1 B2 VGND VNB VPB VPWR Y
.ends

* Black-box entry subcircuit for sky130_fd_sc_hd__o2111ai_2 abstract view
.subckt sky130_fd_sc_hd__o2111ai_2 A1 A2 B1 C1 D1 VGND VNB VPB VPWR Y
.ends

* Black-box entry subcircuit for sky130_fd_sc_hd__nor2_8 abstract view
.subckt sky130_fd_sc_hd__nor2_8 A B VGND VNB VPB VPWR Y
.ends

* Black-box entry subcircuit for sky130_fd_sc_hd__nor3b_2 abstract view
.subckt sky130_fd_sc_hd__nor3b_2 A B C_N VGND VNB VPB VPWR Y
.ends

* Black-box entry subcircuit for sky130_fd_sc_hd__dlygate4sd1_1 abstract view
.subckt sky130_fd_sc_hd__dlygate4sd1_1 A VGND VNB VPB VPWR X
.ends

* Black-box entry subcircuit for sky130_fd_sc_hd__inv_8 abstract view
.subckt sky130_fd_sc_hd__inv_8 A VGND VNB VPB VPWR Y
.ends

* Black-box entry subcircuit for sky130_fd_sc_hd__a211o_2 abstract view
.subckt sky130_fd_sc_hd__a211o_2 A1 A2 B1 C1 VGND VNB VPB VPWR X
.ends

* Black-box entry subcircuit for sky130_fd_sc_hd__o2bb2ai_4 abstract view
.subckt sky130_fd_sc_hd__o2bb2ai_4 A1_N A2_N B1 B2 VGND VNB VPB VPWR Y
.ends

* Black-box entry subcircuit for sky130_fd_sc_hd__and2b_4 abstract view
.subckt sky130_fd_sc_hd__and2b_4 A_N B VGND VNB VPB VPWR X
.ends

* Black-box entry subcircuit for sky130_fd_sc_hd__mux2_2 abstract view
.subckt sky130_fd_sc_hd__mux2_2 A0 A1 S VGND VNB VPB VPWR X
.ends

* Black-box entry subcircuit for sky130_fd_sc_hd__o2bb2a_2 abstract view
.subckt sky130_fd_sc_hd__o2bb2a_2 A1_N A2_N B1 B2 VGND VNB VPB VPWR X
.ends

* Black-box entry subcircuit for sky130_fd_sc_hd__or2_2 abstract view
.subckt sky130_fd_sc_hd__or2_2 A B VGND VNB VPB VPWR X
.ends

* Black-box entry subcircuit for sky130_fd_sc_hd__and3b_2 abstract view
.subckt sky130_fd_sc_hd__and3b_2 A_N B C VGND VNB VPB VPWR X
.ends

* Black-box entry subcircuit for sky130_fd_sc_hd__xor2_4 abstract view
.subckt sky130_fd_sc_hd__xor2_4 A B VGND VNB VPB VPWR X
.ends

* Black-box entry subcircuit for sky130_fd_sc_hd__o22ai_2 abstract view
.subckt sky130_fd_sc_hd__o22ai_2 A1 A2 B1 B2 VGND VNB VPB VPWR Y
.ends

.subckt addsub32 A[0] A[10] A[11] A[12] A[13] A[14] A[15] A[16] A[17] A[18] A[19]
+ A[1] A[20] A[21] A[22] A[23] A[24] A[25] A[26] A[27] A[28] A[29] A[2] A[30] A[31]
+ A[3] A[4] A[5] A[6] A[7] A[8] A[9] B[0] B[10] B[11] B[12] B[13] B[14] B[15] B[16]
+ B[17] B[18] B[19] B[1] B[20] B[21] B[22] B[23] B[24] B[25] B[26] B[27] B[28] B[29]
+ B[2] B[30] B[31] B[3] B[4] B[5] B[6] B[7] B[8] B[9] S[0] S[10] S[11] S[12] S[13]
+ S[14] S[15] S[16] S[17] S[18] S[19] S[1] S[20] S[21] S[22] S[23] S[24] S[25] S[26]
+ S[27] S[28] S[29] S[2] S[30] S[31] S[3] S[4] S[5] S[6] S[7] S[8] S[9] VGND VPWR
+ carryOut sub
XFILLER_22_155 VGND VGND VPWR VPWR sky130_fd_sc_hd__decap_3
XFILLER_22_100 VGND VGND VPWR VPWR sky130_fd_sc_hd__decap_3
XFILLER_13_111 VGND VGND VPWR VPWR sky130_fd_sc_hd__fill_1
X_501_ _499_/X _498_/Y _502_/B1 VGND VGND VPWR VPWR _501_/Y sky130_fd_sc_hd__o21bai_4
X_432_ _659_/A _425_/B _659_/B VGND VGND VPWR VPWR _433_/B sky130_fd_sc_hd__a21bo_2
XTAP_TAPCELL_ROW_15_128 VGND VPWR sky130_fd_sc_hd__tapvpwrvgnd_1
XFILLER_26_85 VGND VGND VPWR VPWR sky130_fd_sc_hd__decap_3
XFILLER_26_63 VGND VGND VPWR VPWR sky130_fd_sc_hd__decap_3
X_363_ _362_/B _363_/B VGND VGND VPWR VPWR _367_/C sky130_fd_sc_hd__nand2b_2
XFILLER_9_148 VGND VGND VPWR VPWR sky130_fd_sc_hd__decap_3
XFILLER_9_104 VGND VGND VPWR VPWR sky130_fd_sc_hd__decap_3
XFILLER_8_181 VGND VGND VPWR VPWR sky130_fd_sc_hd__decap_3
Xfanout105 fanout108/X VGND VGND VPWR VPWR fanout105/X sky130_fd_sc_hd__buf_8
Xfanout116 fanout121/X VGND VGND VPWR VPWR _712_/A sky130_fd_sc_hd__clkbuf_2
XFILLER_10_125 VGND VGND VPWR VPWR sky130_fd_sc_hd__decap_3
XFILLER_10_147 VGND VGND VPWR VPWR sky130_fd_sc_hd__decap_3
XFILLER_10_169 VGND VGND VPWR VPWR sky130_fd_sc_hd__decap_3
XFILLER_6_129 VGND VGND VPWR VPWR sky130_fd_sc_hd__decap_3
XFILLER_12_76 VGND VGND VPWR VPWR sky130_fd_sc_hd__decap_3
X_415_ _640_/D _640_/B _640_/A VGND VGND VPWR VPWR _415_/Y sky130_fd_sc_hd__nand3_4
XFILLER_5_151 VGND VGND VPWR VPWR sky130_fd_sc_hd__decap_3
XFILLER_5_140 VGND VGND VPWR VPWR sky130_fd_sc_hd__fill_1
XFILLER_5_195 VGND VGND VPWR VPWR sky130_fd_sc_hd__fill_2
XFILLER_23_42 VGND VGND VPWR VPWR sky130_fd_sc_hd__decap_3
XFILLER_2_176 VGND VGND VPWR VPWR sky130_fd_sc_hd__decap_3
XFILLER_0_57 VGND VGND VPWR VPWR sky130_fd_sc_hd__decap_3
XFILLER_9_66 VGND VGND VPWR VPWR sky130_fd_sc_hd__decap_3
XFILLER_9_55 VGND VGND VPWR VPWR sky130_fd_sc_hd__fill_1
XFILLER_21_209 VGND VGND VPWR VPWR sky130_fd_sc_hd__fill_2
X_680_ _665_/A _665_/B input6/X VGND VGND VPWR VPWR _680_/Y sky130_fd_sc_hd__o21bai_2
XFILLER_18_97 VGND VGND VPWR VPWR sky130_fd_sc_hd__decap_3
XFILLER_18_53 VGND VGND VPWR VPWR sky130_fd_sc_hd__decap_3
XFILLER_34_52 VGND VGND VPWR VPWR sky130_fd_sc_hd__fill_1
XFILLER_29_139 VGND VGND VPWR VPWR sky130_fd_sc_hd__decap_3
XFILLER_20_32 VGND VGND VPWR VPWR sky130_fd_sc_hd__fill_1
XFILLER_29_41 VGND VGND VPWR VPWR sky130_fd_sc_hd__fill_2
X_594_ _593_/A _593_/B input24/X VGND VGND VPWR VPWR _613_/A sky130_fd_sc_hd__o21ba_2
X_663_ _664_/A _664_/B VGND VGND VPWR VPWR _665_/A sky130_fd_sc_hd__and2_4
XFILLER_28_194 VGND VGND VPWR VPWR sky130_fd_sc_hd__fill_2
XFILLER_26_109 VGND VGND VPWR VPWR sky130_fd_sc_hd__decap_3
XFILLER_19_172 VGND VGND VPWR VPWR sky130_fd_sc_hd__decap_3
XFILLER_19_150 VGND VGND VPWR VPWR sky130_fd_sc_hd__fill_2
XFILLER_34_197 VGND VGND VPWR VPWR sky130_fd_sc_hd__decap_3
Xrebuffer129 _501_/Y VGND VGND VPWR VPWR _505_/B1 sky130_fd_sc_hd__buf_2
XFILLER_1_208 VGND VGND VPWR VPWR sky130_fd_sc_hd__decap_3
XFILLER_25_175 VGND VGND VPWR VPWR sky130_fd_sc_hd__decap_3
XFILLER_25_120 VGND VGND VPWR VPWR sky130_fd_sc_hd__decap_3
Xoutput75 _445_/X VGND VGND VPWR VPWR S[18] sky130_fd_sc_hd__clkbuf_4
XFILLER_31_64 VGND VGND VPWR VPWR sky130_fd_sc_hd__decap_3
X_715_ _715_/A _715_/B VGND VGND VPWR VPWR _716_/B sky130_fd_sc_hd__nand2_4
Xoutput97 _635_/Y VGND VGND VPWR VPWR S[9] sky130_fd_sc_hd__clkbuf_2
Xoutput86 _581_/X VGND VGND VPWR VPWR S[28] sky130_fd_sc_hd__buf_6
XFILLER_16_153 VGND VGND VPWR VPWR sky130_fd_sc_hd__decap_3
X_577_ _577_/A _577_/B VGND VGND VPWR VPWR _605_/A sky130_fd_sc_hd__nand2_8
X_646_ _642_/B _691_/X _679_/Y VGND VGND VPWR VPWR _648_/D sky130_fd_sc_hd__a21o_2
XFILLER_31_123 VGND VGND VPWR VPWR sky130_fd_sc_hd__fill_2
XFILLER_31_189 VGND VGND VPWR VPWR sky130_fd_sc_hd__decap_3
XFILLER_22_167 VGND VGND VPWR VPWR sky130_fd_sc_hd__decap_3
XFILLER_22_112 VGND VGND VPWR VPWR sky130_fd_sc_hd__decap_3
X_500_ _498_/Y _499_/X _502_/B1 VGND VGND VPWR VPWR _500_/X sky130_fd_sc_hd__o21ba_2
XFILLER_13_145 VGND VGND VPWR VPWR sky130_fd_sc_hd__decap_3
X_431_ _442_/B _443_/A VGND VGND VPWR VPWR _464_/B sky130_fd_sc_hd__nand2_2
X_362_ _727_/A _362_/B VGND VGND VPWR VPWR _367_/B sky130_fd_sc_hd__nand2_2
XTAP_TAPCELL_ROW_15_129 VGND VPWR sky130_fd_sc_hd__tapvpwrvgnd_1
XFILLER_26_97 VGND VGND VPWR VPWR sky130_fd_sc_hd__decap_3
XFILLER_26_75 VGND VGND VPWR VPWR sky130_fd_sc_hd__decap_3
X_629_ _629_/A _629_/B VGND VGND VPWR VPWR _629_/Y sky130_fd_sc_hd__xnor2_2
XFILLER_8_193 VGND VGND VPWR VPWR sky130_fd_sc_hd__decap_3
Xfanout106 fanout108/X VGND VGND VPWR VPWR _363_/B sky130_fd_sc_hd__buf_2
Xfanout117 fanout121/X VGND VGND VPWR VPWR _533_/A sky130_fd_sc_hd__buf_6
XFILLER_10_137 VGND VGND VPWR VPWR sky130_fd_sc_hd__decap_3
XFILLER_10_159 VGND VGND VPWR VPWR sky130_fd_sc_hd__fill_2
XFILLER_12_55 VGND VGND VPWR VPWR sky130_fd_sc_hd__decap_3
XFILLER_12_88 VGND VGND VPWR VPWR sky130_fd_sc_hd__decap_3
XFILLER_6_119 VGND VGND VPWR VPWR sky130_fd_sc_hd__fill_1
X_414_ _412_/Y _723_/X _413_/X VGND VGND VPWR VPWR _640_/D sky130_fd_sc_hd__a21oi_4
XFILLER_5_185 VGND VGND VPWR VPWR sky130_fd_sc_hd__decap_3
XFILLER_5_163 VGND VGND VPWR VPWR sky130_fd_sc_hd__decap_3
XPHY_EDGE_ROW_12_Right_12 VGND VGND VPWR VPWR sky130_fd_sc_hd__decap_3
XPHY_EDGE_ROW_21_Right_21 VGND VGND VPWR VPWR sky130_fd_sc_hd__decap_3
XFILLER_23_54 VGND VGND VPWR VPWR sky130_fd_sc_hd__fill_2
XPHY_EDGE_ROW_30_Right_30 VGND VGND VPWR VPWR sky130_fd_sc_hd__decap_3
XFILLER_23_87 VGND VGND VPWR VPWR sky130_fd_sc_hd__decap_3
XFILLER_20_210 VGND VGND VPWR VPWR sky130_fd_sc_hd__fill_1
XFILLER_18_65 VGND VGND VPWR VPWR sky130_fd_sc_hd__decap_3
XFILLER_18_43 VGND VGND VPWR VPWR sky130_fd_sc_hd__fill_1
XPHY_EDGE_ROW_28_Left_64 VGND VGND VPWR VPWR sky130_fd_sc_hd__decap_3
XPHY_EDGE_ROW_12_Left_48 VGND VGND VPWR VPWR sky130_fd_sc_hd__decap_3
XFILLER_4_206 VGND VGND VPWR VPWR sky130_fd_sc_hd__decap_3
XFILLER_20_99 VGND VGND VPWR VPWR sky130_fd_sc_hd__decap_3
XFILLER_20_55 VGND VGND VPWR VPWR sky130_fd_sc_hd__fill_1
X_662_ _662_/A _662_/B input7/X VGND VGND VPWR VPWR _692_/A sky130_fd_sc_hd__or3b_4
X_593_ _593_/A _593_/B input24/X VGND VGND VPWR VPWR _605_/B sky130_fd_sc_hd__or3b_2
XFILLER_28_173 VGND VGND VPWR VPWR sky130_fd_sc_hd__fill_2
XFILLER_6_79 VGND VGND VPWR VPWR sky130_fd_sc_hd__decap_3
XFILLER_34_165 VGND VGND VPWR VPWR sky130_fd_sc_hd__decap_3
XPHY_EDGE_ROW_6_Right_6 VGND VGND VPWR VPWR sky130_fd_sc_hd__decap_3
XFILLER_25_110 VGND VGND VPWR VPWR sky130_fd_sc_hd__fill_2
XFILLER_15_88 VGND VGND VPWR VPWR sky130_fd_sc_hd__decap_3
XFILLER_31_76 VGND VGND VPWR VPWR sky130_fd_sc_hd__decap_3
Xoutput98 _651_/Y VGND VGND VPWR VPWR carryOut sky130_fd_sc_hd__buf_6
Xoutput87 _590_/Y VGND VGND VPWR VPWR S[29] sky130_fd_sc_hd__buf_6
Xoutput76 _457_/Y VGND VGND VPWR VPWR S[19] sky130_fd_sc_hd__clkbuf_4
XFILLER_16_121 VGND VGND VPWR VPWR sky130_fd_sc_hd__decap_3
X_645_ _689_/Y _641_/Y _691_/B _677_/Y VGND VGND VPWR VPWR _647_/B sky130_fd_sc_hd__o211ai_2
X_714_ _712_/A _712_/B input2/X VGND VGND VPWR VPWR _715_/A sky130_fd_sc_hd__o21a_4
XTAP_TAPCELL_ROW_18_138 VGND VPWR sky130_fd_sc_hd__tapvpwrvgnd_1
XFILLER_16_165 VGND VGND VPWR VPWR sky130_fd_sc_hd__decap_3
X_576_ _573_/A _576_/A2 _572_/X VGND VGND VPWR VPWR _576_/Y sky130_fd_sc_hd__o21ai_2
XFILLER_22_124 VGND VGND VPWR VPWR sky130_fd_sc_hd__decap_3
XFILLER_22_179 VGND VGND VPWR VPWR sky130_fd_sc_hd__decap_3
XPHY_EDGE_ROW_15_Left_51 VGND VGND VPWR VPWR sky130_fd_sc_hd__decap_3
XFILLER_26_32 VGND VGND VPWR VPWR sky130_fd_sc_hd__decap_3
XFILLER_13_102 VGND VGND VPWR VPWR sky130_fd_sc_hd__decap_3
XFILLER_13_113 VGND VGND VPWR VPWR sky130_fd_sc_hd__decap_3
XFILLER_13_157 VGND VGND VPWR VPWR sky130_fd_sc_hd__fill_1
X_430_ _426_/Y _427_/X _429_/C VGND VGND VPWR VPWR _443_/A sky130_fd_sc_hd__o21bai_4
X_361_ _363_/B _362_/B VGND VGND VPWR VPWR _361_/X sky130_fd_sc_hd__and2_2
XFILLER_9_139 VGND VGND VPWR VPWR sky130_fd_sc_hd__decap_3
XFILLER_26_54 VGND VGND VPWR VPWR sky130_fd_sc_hd__decap_3
XFILLER_26_43 VGND VGND VPWR VPWR sky130_fd_sc_hd__fill_1
X_628_ _358_/B _357_/Y _627_/B _356_/Y VGND VGND VPWR VPWR _629_/B sky130_fd_sc_hd__a22oi_2
X_559_ _520_/Y _559_/A2 _558_/X VGND VGND VPWR VPWR _559_/Y sky130_fd_sc_hd__a21oi_4
XFILLER_8_150 VGND VGND VPWR VPWR sky130_fd_sc_hd__decap_3
XFILLER_12_67 VGND VGND VPWR VPWR sky130_fd_sc_hd__decap_3
XPHY_EDGE_ROW_0_Left_36 VGND VGND VPWR VPWR sky130_fd_sc_hd__decap_3
XFILLER_5_6 VGND VGND VPWR VPWR sky130_fd_sc_hd__fill_1
X_413_ _715_/B _721_/Y _715_/A _719_/Y VGND VGND VPWR VPWR _413_/X sky130_fd_sc_hd__a31o_2
XFILLER_33_208 VGND VGND VPWR VPWR sky130_fd_sc_hd__decap_3
XFILLER_23_33 VGND VGND VPWR VPWR sky130_fd_sc_hd__decap_3
XFILLER_3_3 VGND VGND VPWR VPWR sky130_fd_sc_hd__fill_2
XFILLER_2_123 VGND VGND VPWR VPWR sky130_fd_sc_hd__decap_3
XFILLER_0_15 VGND VGND VPWR VPWR sky130_fd_sc_hd__decap_3
XFILLER_9_79 VGND VGND VPWR VPWR sky130_fd_sc_hd__decap_3
XFILLER_9_57 VGND VGND VPWR VPWR sky130_fd_sc_hd__decap_3
XFILLER_9_46 VGND VGND VPWR VPWR sky130_fd_sc_hd__decap_3
XFILLER_20_200 VGND VGND VPWR VPWR sky130_fd_sc_hd__decap_3
XFILLER_34_21 VGND VGND VPWR VPWR sky130_fd_sc_hd__decap_3
XFILLER_18_88 VGND VGND VPWR VPWR sky130_fd_sc_hd__fill_1
XFILLER_18_77 VGND VGND VPWR VPWR sky130_fd_sc_hd__decap_3
Xload_slew118 _533_/A VGND VGND VPWR VPWR _664_/A sky130_fd_sc_hd__buf_8
Xload_slew107 _363_/B VGND VGND VPWR VPWR _728_/A sky130_fd_sc_hd__buf_6
X_592_ _592_/A _592_/B VGND VGND VPWR VPWR _593_/B sky130_fd_sc_hd__and2_2
X_661_ _664_/A _661_/B VGND VGND VPWR VPWR _662_/A sky130_fd_sc_hd__and2_4
X_730_ _728_/A _728_/B _730_/B1 VGND VGND VPWR VPWR _730_/Y sky130_fd_sc_hd__o21ai_4
XFILLER_28_152 VGND VGND VPWR VPWR sky130_fd_sc_hd__fill_1
XFILLER_28_141 VGND VGND VPWR VPWR sky130_fd_sc_hd__decap_3
XFILLER_20_6 VGND VGND VPWR VPWR sky130_fd_sc_hd__fill_1
XFILLER_15_45 VGND VGND VPWR VPWR sky130_fd_sc_hd__decap_3
XFILLER_25_166 VGND VGND VPWR VPWR sky130_fd_sc_hd__fill_2
XFILLER_25_100 VGND VGND VPWR VPWR sky130_fd_sc_hd__fill_1
XFILLER_31_44 VGND VGND VPWR VPWR sky130_fd_sc_hd__decap_3
XFILLER_31_33 VGND VGND VPWR VPWR sky130_fd_sc_hd__decap_3
Xoutput88 _620_/X VGND VGND VPWR VPWR S[2] sky130_fd_sc_hd__buf_4
Xoutput77 _617_/Y VGND VGND VPWR VPWR S[1] sky130_fd_sc_hd__buf_6
Xoutput66 _615_/X VGND VGND VPWR VPWR S[0] sky130_fd_sc_hd__clkdlybuf4s25_1
XFILLER_16_133 VGND VGND VPWR VPWR sky130_fd_sc_hd__decap_3
XFILLER_16_144 VGND VGND VPWR VPWR sky130_fd_sc_hd__decap_3
X_575_ _575_/A1 _573_/A _572_/X VGND VGND VPWR VPWR _577_/A sky130_fd_sc_hd__o21a_4
X_644_ _689_/Y _644_/B VGND VGND VPWR VPWR _644_/Y sky130_fd_sc_hd__xnor2_2
X_713_ input2/X _713_/B _713_/C VGND VGND VPWR VPWR _716_/A sky130_fd_sc_hd__nand3b_2
XTAP_TAPCELL_ROW_18_139 VGND VPWR sky130_fd_sc_hd__tapvpwrvgnd_1
XFILLER_16_177 VGND VGND VPWR VPWR sky130_fd_sc_hd__fill_2
XFILLER_31_169 VGND VGND VPWR VPWR sky130_fd_sc_hd__decap_3
XFILLER_22_158 VGND VGND VPWR VPWR sky130_fd_sc_hd__decap_3
XFILLER_22_103 VGND VGND VPWR VPWR sky130_fd_sc_hd__decap_3
XTAP_TAPCELL_ROW_9_107 VGND VPWR sky130_fd_sc_hd__tapvpwrvgnd_1
XFILLER_26_66 VGND VGND VPWR VPWR sky130_fd_sc_hd__decap_3
XFILLER_13_125 VGND VGND VPWR VPWR sky130_fd_sc_hd__fill_1
XFILLER_13_136 VGND VGND VPWR VPWR sky130_fd_sc_hd__decap_3
X_360_ _730_/Y _728_/X _356_/Y _358_/Y _729_/Y VGND VGND VPWR VPWR _378_/A sky130_fd_sc_hd__o2111ai_4
XFILLER_9_107 VGND VGND VPWR VPWR sky130_fd_sc_hd__decap_3
XFILLER_26_88 VGND VGND VPWR VPWR sky130_fd_sc_hd__decap_3
X_558_ _558_/A _558_/B _571_/B VGND VGND VPWR VPWR _558_/X sky130_fd_sc_hd__or3b_2
X_627_ _627_/A _627_/B VGND VGND VPWR VPWR _627_/Y sky130_fd_sc_hd__xnor2_2
X_489_ _499_/A _490_/B VGND VGND VPWR VPWR _489_/X sky130_fd_sc_hd__and2_4
XFILLER_8_184 VGND VGND VPWR VPWR sky130_fd_sc_hd__decap_3
Xfanout108 input65/X VGND VGND VPWR VPWR fanout108/X sky130_fd_sc_hd__buf_6
Xfanout119 fanout121/X VGND VGND VPWR VPWR fanout119/X sky130_fd_sc_hd__buf_8
XFILLER_10_128 VGND VGND VPWR VPWR sky130_fd_sc_hd__decap_3
XFILLER_12_46 VGND VGND VPWR VPWR sky130_fd_sc_hd__decap_3
XFILLER_12_79 VGND VGND VPWR VPWR sky130_fd_sc_hd__decap_3
XTAP_TAPCELL_ROW_20_145 VGND VPWR sky130_fd_sc_hd__tapvpwrvgnd_1
X_412_ _709_/C _696_/X _709_/B VGND VGND VPWR VPWR _412_/Y sky130_fd_sc_hd__o21ai_2
XFILLER_5_176 VGND VGND VPWR VPWR sky130_fd_sc_hd__decap_3
XFILLER_5_154 VGND VGND VPWR VPWR sky130_fd_sc_hd__decap_3
XFILLER_23_45 VGND VGND VPWR VPWR sky130_fd_sc_hd__decap_3
XFILLER_9_69 VGND VGND VPWR VPWR sky130_fd_sc_hd__fill_2
XFILLER_18_56 VGND VGND VPWR VPWR sky130_fd_sc_hd__decap_3
XFILLER_1_70 VGND VGND VPWR VPWR sky130_fd_sc_hd__fill_2
X_591_ _592_/A _592_/B VGND VGND VPWR VPWR _593_/A sky130_fd_sc_hd__nor2_2
X_660_ _664_/A _661_/B VGND VGND VPWR VPWR _662_/B sky130_fd_sc_hd__nor2_2
XFILLER_29_55 VGND VGND VPWR VPWR sky130_fd_sc_hd__fill_1
XFILLER_6_26 VGND VGND VPWR VPWR sky130_fd_sc_hd__fill_2
XFILLER_19_175 VGND VGND VPWR VPWR sky130_fd_sc_hd__decap_3
XFILLER_25_123 VGND VGND VPWR VPWR sky130_fd_sc_hd__fill_2
XFILLER_15_57 VGND VGND VPWR VPWR sky130_fd_sc_hd__fill_1
XFILLER_15_79 VGND VGND VPWR VPWR sky130_fd_sc_hd__decap_3
XFILLER_25_178 VGND VGND VPWR VPWR sky130_fd_sc_hd__fill_1
XFILLER_31_67 VGND VGND VPWR VPWR sky130_fd_sc_hd__decap_3
XFILLER_0_200 VGND VGND VPWR VPWR sky130_fd_sc_hd__decap_3
X_712_ _712_/A _712_/B VGND VGND VPWR VPWR _715_/B sky130_fd_sc_hd__nand2_2
Xoutput89 _604_/Y VGND VGND VPWR VPWR S[30] sky130_fd_sc_hd__buf_6
Xoutput78 _471_/X VGND VGND VPWR VPWR S[20] sky130_fd_sc_hd__buf_6
Xoutput67 _637_/X VGND VGND VPWR VPWR S[10] sky130_fd_sc_hd__dlymetal6s4s_1
XFILLER_16_112 VGND VGND VPWR VPWR sky130_fd_sc_hd__decap_3
XFILLER_16_156 VGND VGND VPWR VPWR sky130_fd_sc_hd__decap_3
X_574_ _685_/Y _574_/A2 _422_/Y _574_/B2 _573_/Y VGND VGND VPWR VPWR _577_/B sky130_fd_sc_hd__o221ai_4
X_643_ _677_/C _677_/B _642_/B _692_/D VGND VGND VPWR VPWR _644_/B sky130_fd_sc_hd__a22o_2
XFILLER_31_137 VGND VGND VPWR VPWR sky130_fd_sc_hd__decap_3
XFILLER_11_3 VGND VGND VPWR VPWR sky130_fd_sc_hd__decap_3
XFILLER_22_115 VGND VGND VPWR VPWR sky130_fd_sc_hd__decap_3
XTAP_TAPCELL_ROW_9_108 VGND VPWR sky130_fd_sc_hd__tapvpwrvgnd_1
XTAP_TAPCELL_ROW_32_187 VGND VPWR sky130_fd_sc_hd__tapvpwrvgnd_1
XFILLER_7_80 VGND VGND VPWR VPWR sky130_fd_sc_hd__decap_3
XFILLER_26_78 VGND VGND VPWR VPWR sky130_fd_sc_hd__decap_3
XFILLER_13_148 VGND VGND VPWR VPWR sky130_fd_sc_hd__decap_3
X_557_ _557_/A _556_/X VGND VGND VPWR VPWR _571_/C sky130_fd_sc_hd__nor2b_4
X_626_ _361_/X _364_/Y _366_/X _625_/B VGND VGND VPWR VPWR _627_/B sky130_fd_sc_hd__o22a_4
X_488_ _499_/A _490_/B VGND VGND VPWR VPWR _488_/Y sky130_fd_sc_hd__nor2_4
XFILLER_8_141 VGND VGND VPWR VPWR sky130_fd_sc_hd__fill_2
Xfanout109 input65/X VGND VGND VPWR VPWR _606_/A sky130_fd_sc_hd__clkbuf_2
XTAP_TAPCELL_ROW_20_146 VGND VPWR sky130_fd_sc_hd__tapvpwrvgnd_1
XFILLER_12_58 VGND VGND VPWR VPWR sky130_fd_sc_hd__decap_3
X_411_ _411_/A _725_/Y _411_/C VGND VGND VPWR VPWR _640_/B sky130_fd_sc_hd__nand3_4
XFILLER_5_188 VGND VGND VPWR VPWR sky130_fd_sc_hd__fill_2
XFILLER_5_166 VGND VGND VPWR VPWR sky130_fd_sc_hd__fill_2
X_609_ _613_/A _601_/A _613_/B _605_/B VGND VGND VPWR VPWR _609_/X sky130_fd_sc_hd__o211a_2
XFILLER_23_68 VGND VGND VPWR VPWR sky130_fd_sc_hd__decap_3
XFILLER_23_57 VGND VGND VPWR VPWR sky130_fd_sc_hd__decap_3
XFILLER_14_210 VGND VGND VPWR VPWR sky130_fd_sc_hd__fill_1
XFILLER_13_90 VGND VGND VPWR VPWR sky130_fd_sc_hd__decap_3
XFILLER_18_68 VGND VGND VPWR VPWR sky130_fd_sc_hd__decap_3
XFILLER_4_209 VGND VGND VPWR VPWR sky130_fd_sc_hd__fill_2
XFILLER_20_25 VGND VGND VPWR VPWR sky130_fd_sc_hd__decap_3
X_590_ _568_/Y _588_/Y _589_/Y VGND VGND VPWR VPWR _590_/Y sky130_fd_sc_hd__o21ai_2
XFILLER_10_91 VGND VGND VPWR VPWR sky130_fd_sc_hd__decap_3
XFILLER_19_110 VGND VGND VPWR VPWR sky130_fd_sc_hd__fill_2
X_642_ _692_/D _642_/B VGND VGND VPWR VPWR _642_/X sky130_fd_sc_hd__xor2_2
X_711_ _727_/A _712_/B VGND VGND VPWR VPWR _713_/C sky130_fd_sc_hd__nand2_2
Xoutput79 _482_/Y VGND VGND VPWR VPWR S[21] sky130_fd_sc_hd__buf_8
Xoutput68 _639_/X VGND VGND VPWR VPWR S[11] sky130_fd_sc_hd__clkbuf_2
XFILLER_16_124 VGND VGND VPWR VPWR sky130_fd_sc_hd__decap_3
XFILLER_16_168 VGND VGND VPWR VPWR sky130_fd_sc_hd__decap_3
X_573_ _573_/A _573_/B VGND VGND VPWR VPWR _573_/Y sky130_fd_sc_hd__nor2_4
XPHY_EDGE_ROW_19_Right_19 VGND VGND VPWR VPWR sky130_fd_sc_hd__decap_3
XPHY_EDGE_ROW_28_Right_28 VGND VGND VPWR VPWR sky130_fd_sc_hd__decap_3
XTAP_TAPCELL_ROW_32_188 VGND VPWR sky130_fd_sc_hd__tapvpwrvgnd_1
XFILLER_30_160 VGND VGND VPWR VPWR sky130_fd_sc_hd__decap_3
XFILLER_22_149 VGND VGND VPWR VPWR sky130_fd_sc_hd__decap_3
XFILLER_22_127 VGND VGND VPWR VPWR sky130_fd_sc_hd__fill_1
XTAP_TAPCELL_ROW_9_109 VGND VPWR sky130_fd_sc_hd__tapvpwrvgnd_1
XFILLER_13_105 VGND VGND VPWR VPWR sky130_fd_sc_hd__decap_3
XFILLER_13_116 VGND VGND VPWR VPWR sky130_fd_sc_hd__fill_1
XFILLER_26_57 VGND VGND VPWR VPWR sky130_fd_sc_hd__decap_3
XFILLER_21_193 VGND VGND VPWR VPWR sky130_fd_sc_hd__decap_3
X_625_ _625_/A _625_/B VGND VGND VPWR VPWR _625_/Y sky130_fd_sc_hd__xnor2_2
X_556_ _556_/A _556_/B input20/X VGND VGND VPWR VPWR _556_/X sky130_fd_sc_hd__or3b_2
X_487_ _487_/A1_N _506_/A _474_/X _484_/X VGND VGND VPWR VPWR _496_/A sky130_fd_sc_hd__o2bb2ai_2
XFILLER_8_153 VGND VGND VPWR VPWR sky130_fd_sc_hd__decap_3
XPHY_EDGE_ROW_19_Left_55 VGND VGND VPWR VPWR sky130_fd_sc_hd__decap_3
XFILLER_10_119 VGND VGND VPWR VPWR sky130_fd_sc_hd__decap_3
XTAP_TAPCELL_ROW_20_147 VGND VPWR sky130_fd_sc_hd__tapvpwrvgnd_1
X_410_ _410_/A _420_/B _410_/C _725_/Y VGND VGND VPWR VPWR _640_/A sky130_fd_sc_hd__nand4_4
XTAP_TAPCELL_ROW_11_114 VGND VPWR sky130_fd_sc_hd__tapvpwrvgnd_1
XFILLER_5_134 VGND VGND VPWR VPWR sky130_fd_sc_hd__decap_3
XFILLER_5_101 VGND VGND VPWR VPWR sky130_fd_sc_hd__decap_3
X_608_ _585_/X _597_/B _597_/C _605_/B VGND VGND VPWR VPWR _611_/B sky130_fd_sc_hd__o211a_2
XFILLER_32_200 VGND VGND VPWR VPWR sky130_fd_sc_hd__decap_3
X_539_ _524_/X _528_/Y _558_/B VGND VGND VPWR VPWR _540_/B sky130_fd_sc_hd__o21ai_2
XFILLER_23_36 VGND VGND VPWR VPWR sky130_fd_sc_hd__decap_3
XFILLER_0_18 VGND VGND VPWR VPWR sky130_fd_sc_hd__fill_2
XFILLER_0_29 VGND VGND VPWR VPWR sky130_fd_sc_hd__decap_3
XFILLER_9_49 VGND VGND VPWR VPWR sky130_fd_sc_hd__decap_3
XTAP_TAPCELL_ROW_0_72 VGND VPWR sky130_fd_sc_hd__tapvpwrvgnd_1
XFILLER_34_68 VGND VGND VPWR VPWR sky130_fd_sc_hd__fill_1
XFILLER_34_24 VGND VGND VPWR VPWR sky130_fd_sc_hd__decap_3
XFILLER_1_3 VGND VGND VPWR VPWR sky130_fd_sc_hd__decap_3
XFILLER_29_57 VGND VGND VPWR VPWR sky130_fd_sc_hd__decap_3
XFILLER_28_100 VGND VGND VPWR VPWR sky130_fd_sc_hd__fill_1
XFILLER_28_144 VGND VGND VPWR VPWR sky130_fd_sc_hd__fill_1
XPHY_EDGE_ROW_7_Left_43 VGND VGND VPWR VPWR sky130_fd_sc_hd__decap_3
XFILLER_10_81 VGND VGND VPWR VPWR sky130_fd_sc_hd__decap_3
XFILLER_3_210 VGND VGND VPWR VPWR sky130_fd_sc_hd__fill_1
XFILLER_34_114 VGND VGND VPWR VPWR sky130_fd_sc_hd__decap_3
XFILLER_19_90 VGND VGND VPWR VPWR sky130_fd_sc_hd__decap_3
XFILLER_25_169 VGND VGND VPWR VPWR sky130_fd_sc_hd__decap_3
XFILLER_31_47 VGND VGND VPWR VPWR sky130_fd_sc_hd__fill_2
XFILLER_31_36 VGND VGND VPWR VPWR sky130_fd_sc_hd__fill_1
Xoutput69 _642_/X VGND VGND VPWR VPWR S[12] sky130_fd_sc_hd__dlymetal6s4s_1
XPHY_EDGE_ROW_33_Left_69 VGND VGND VPWR VPWR sky130_fd_sc_hd__decap_3
X_572_ _557_/A _563_/A _556_/X VGND VGND VPWR VPWR _572_/X sky130_fd_sc_hd__o21a_2
X_641_ _642_/B _692_/D VGND VGND VPWR VPWR _641_/Y sky130_fd_sc_hd__nand2_2
X_710_ _712_/B _712_/A VGND VGND VPWR VPWR _713_/B sky130_fd_sc_hd__nand2b_2
XFILLER_16_136 VGND VGND VPWR VPWR sky130_fd_sc_hd__decap_3
XFILLER_16_147 VGND VGND VPWR VPWR sky130_fd_sc_hd__decap_3
XFILLER_31_117 VGND VGND VPWR VPWR sky130_fd_sc_hd__decap_3
XFILLER_24_180 VGND VGND VPWR VPWR sky130_fd_sc_hd__decap_3
XFILLER_21_80 VGND VGND VPWR VPWR sky130_fd_sc_hd__decap_3
XFILLER_22_106 VGND VGND VPWR VPWR sky130_fd_sc_hd__decap_3
XTAP_TAPCELL_ROW_32_189 VGND VPWR sky130_fd_sc_hd__tapvpwrvgnd_1
XFILLER_30_172 VGND VGND VPWR VPWR sky130_fd_sc_hd__decap_3
XFILLER_7_60 VGND VGND VPWR VPWR sky130_fd_sc_hd__fill_2
XFILLER_13_139 VGND VGND VPWR VPWR sky130_fd_sc_hd__decap_3
XFILLER_26_69 VGND VGND VPWR VPWR sky130_fd_sc_hd__decap_3
XTAP_TAPCELL_ROW_23_156 VGND VPWR sky130_fd_sc_hd__tapvpwrvgnd_1
XFILLER_21_172 VGND VGND VPWR VPWR sky130_fd_sc_hd__decap_3
XFILLER_21_161 VGND VGND VPWR VPWR sky130_fd_sc_hd__decap_3
X_555_ _556_/A _556_/B input20/X VGND VGND VPWR VPWR _557_/A sky130_fd_sc_hd__o21ba_2
X_624_ _410_/C _410_/A _420_/A VGND VGND VPWR VPWR _625_/B sky130_fd_sc_hd__a21oi_2
XFILLER_12_150 VGND VGND VPWR VPWR sky130_fd_sc_hd__fill_2
XFILLER_16_80 VGND VGND VPWR VPWR sky130_fd_sc_hd__decap_3
XFILLER_16_91 VGND VGND VPWR VPWR sky130_fd_sc_hd__fill_2
X_486_ _486_/A VGND VGND VPWR VPWR _486_/Y sky130_fd_sc_hd__inv_2
XFILLER_8_187 VGND VGND VPWR VPWR sky130_fd_sc_hd__fill_1
XFILLER_12_49 VGND VGND VPWR VPWR sky130_fd_sc_hd__decap_3
XTAP_TAPCELL_ROW_20_148 VGND VPWR sky130_fd_sc_hd__tapvpwrvgnd_1
XFILLER_18_209 VGND VGND VPWR VPWR sky130_fd_sc_hd__fill_2
XTAP_TAPCELL_ROW_11_115 VGND VPWR sky130_fd_sc_hd__tapvpwrvgnd_1
XFILLER_5_179 VGND VGND VPWR VPWR sky130_fd_sc_hd__decap_3
XFILLER_5_157 VGND VGND VPWR VPWR sky130_fd_sc_hd__decap_3
XFILLER_5_113 VGND VGND VPWR VPWR sky130_fd_sc_hd__decap_3
X_538_ _558_/B _538_/B _538_/C VGND VGND VPWR VPWR _540_/A sky130_fd_sc_hd__nand3b_2
X_607_ _607_/A _607_/B VGND VGND VPWR VPWR _613_/B sky130_fd_sc_hd__xnor2_2
XPHY_EDGE_ROW_20_Left_56 VGND VGND VPWR VPWR sky130_fd_sc_hd__decap_3
X_469_ _467_/Y _468_/Y _466_/B VGND VGND VPWR VPWR _469_/Y sky130_fd_sc_hd__o21ai_2
XFILLER_4_72 VGND VGND VPWR VPWR sky130_fd_sc_hd__decap_3
XFILLER_4_190 VGND VGND VPWR VPWR sky130_fd_sc_hd__decap_3
XFILLER_23_48 VGND VGND VPWR VPWR sky130_fd_sc_hd__decap_3
XFILLER_13_81 VGND VGND VPWR VPWR sky130_fd_sc_hd__decap_3
XTAP_TAPCELL_ROW_0_73 VGND VPWR sky130_fd_sc_hd__tapvpwrvgnd_1
XFILLER_18_59 VGND VGND VPWR VPWR sky130_fd_sc_hd__decap_3
XFILLER_20_49 VGND VGND VPWR VPWR sky130_fd_sc_hd__decap_3
XFILLER_28_167 VGND VGND VPWR VPWR sky130_fd_sc_hd__decap_3
XFILLER_6_29 VGND VGND VPWR VPWR sky130_fd_sc_hd__decap_3
XFILLER_10_60 VGND VGND VPWR VPWR sky130_fd_sc_hd__decap_3
XFILLER_19_80 VGND VGND VPWR VPWR sky130_fd_sc_hd__decap_3
XFILLER_19_178 VGND VGND VPWR VPWR sky130_fd_sc_hd__decap_3
XFILLER_25_104 VGND VGND VPWR VPWR sky130_fd_sc_hd__decap_3
XTAP_TAPCELL_ROW_35_198 VGND VPWR sky130_fd_sc_hd__tapvpwrvgnd_1
XFILLER_0_203 VGND VGND VPWR VPWR sky130_fd_sc_hd__decap_3
XPHY_EDGE_ROW_1_Right_1 VGND VGND VPWR VPWR sky130_fd_sc_hd__decap_3
XFILLER_16_115 VGND VGND VPWR VPWR sky130_fd_sc_hd__decap_3
X_571_ _571_/A _571_/B _571_/C VGND VGND VPWR VPWR _573_/A sky130_fd_sc_hd__nand3_4
X_640_ _640_/A _640_/B _640_/C _640_/D VGND VGND VPWR VPWR _642_/B sky130_fd_sc_hd__nand4_2
XFILLER_16_159 VGND VGND VPWR VPWR sky130_fd_sc_hd__decap_3
XFILLER_22_118 VGND VGND VPWR VPWR sky130_fd_sc_hd__decap_3
XFILLER_30_195 VGND VGND VPWR VPWR sky130_fd_sc_hd__fill_1
XTAP_TAPCELL_ROW_23_157 VGND VPWR sky130_fd_sc_hd__tapvpwrvgnd_1
X_554_ _664_/A _554_/B VGND VGND VPWR VPWR _556_/B sky130_fd_sc_hd__and2_4
X_623_ _621_/Y _623_/B VGND VGND VPWR VPWR _623_/Y sky130_fd_sc_hd__nand2b_2
X_485_ _515_/A _477_/Y _475_/Y VGND VGND VPWR VPWR _486_/A sky130_fd_sc_hd__o21ai_2
XTAP_TAPCELL_ROW_14_124 VGND VPWR sky130_fd_sc_hd__tapvpwrvgnd_1
XFILLER_8_111 VGND VGND VPWR VPWR sky130_fd_sc_hd__fill_2
XFILLER_26_210 VGND VGND VPWR VPWR sky130_fd_sc_hd__fill_1
XTAP_TAPCELL_ROW_11_116 VGND VPWR sky130_fd_sc_hd__tapvpwrvgnd_1
X_537_ _533_/X _535_/Y _534_/X VGND VGND VPWR VPWR _558_/B sky130_fd_sc_hd__o21bai_2
X_606_ _606_/A _606_/B VGND VGND VPWR VPWR _607_/B sky130_fd_sc_hd__xor2_2
X_468_ _438_/C _437_/Y _443_/B _443_/A VGND VGND VPWR VPWR _468_/Y sky130_fd_sc_hd__a22oi_2
X_399_ _426_/A _400_/B VGND VGND VPWR VPWR _399_/X sky130_fd_sc_hd__and2_4
XFILLER_4_51 VGND VGND VPWR VPWR sky130_fd_sc_hd__fill_1
XFILLER_13_60 VGND VGND VPWR VPWR sky130_fd_sc_hd__decap_3
XFILLER_13_93 VGND VGND VPWR VPWR sky130_fd_sc_hd__decap_3
XTAP_TAPCELL_ROW_0_74 VGND VPWR sky130_fd_sc_hd__tapvpwrvgnd_1
XFILLER_1_172 VGND VGND VPWR VPWR sky130_fd_sc_hd__decap_3
XFILLER_34_15 VGND VGND VPWR VPWR sky130_fd_sc_hd__decap_3
XFILLER_28_135 VGND VGND VPWR VPWR sky130_fd_sc_hd__decap_3
XFILLER_3_201 VGND VGND VPWR VPWR sky130_fd_sc_hd__decap_3
XFILLER_10_72 VGND VGND VPWR VPWR sky130_fd_sc_hd__decap_3
XFILLER_10_94 VGND VGND VPWR VPWR sky130_fd_sc_hd__decap_3
XFILLER_34_138 VGND VGND VPWR VPWR sky130_fd_sc_hd__fill_2
XFILLER_15_39 VGND VGND VPWR VPWR sky130_fd_sc_hd__decap_3
XTAP_TAPCELL_ROW_35_199 VGND VPWR sky130_fd_sc_hd__tapvpwrvgnd_1
XFILLER_33_193 VGND VGND VPWR VPWR sky130_fd_sc_hd__decap_3
XFILLER_31_27 VGND VGND VPWR VPWR sky130_fd_sc_hd__decap_3
XFILLER_16_127 VGND VGND VPWR VPWR sky130_fd_sc_hd__decap_3
X_570_ _597_/A _597_/B VGND VGND VPWR VPWR _570_/Y sky130_fd_sc_hd__nand2_2
XTAP_TAPCELL_ROW_26_166 VGND VPWR sky130_fd_sc_hd__tapvpwrvgnd_1
XFILLER_31_108 VGND VGND VPWR VPWR sky130_fd_sc_hd__decap_3
XFILLER_24_171 VGND VGND VPWR VPWR sky130_fd_sc_hd__decap_3
XFILLER_21_60 VGND VGND VPWR VPWR sky130_fd_sc_hd__fill_1
X_699_ _717_/A _695_/B _698_/Y VGND VGND VPWR VPWR _709_/B sky130_fd_sc_hd__o21ai_2
XFILLER_30_185 VGND VGND VPWR VPWR sky130_fd_sc_hd__decap_3
XFILLER_30_163 VGND VGND VPWR VPWR sky130_fd_sc_hd__decap_3
XFILLER_30_141 VGND VGND VPWR VPWR sky130_fd_sc_hd__decap_3
XPHY_EDGE_ROW_15_Right_15 VGND VGND VPWR VPWR sky130_fd_sc_hd__decap_3
XPHY_EDGE_ROW_24_Right_24 VGND VGND VPWR VPWR sky130_fd_sc_hd__decap_3
XFILLER_13_108 VGND VGND VPWR VPWR sky130_fd_sc_hd__decap_3
XTAP_TAPCELL_ROW_23_158 VGND VPWR sky130_fd_sc_hd__tapvpwrvgnd_1
XFILLER_21_196 VGND VGND VPWR VPWR sky130_fd_sc_hd__fill_1
XPHY_EDGE_ROW_33_Right_33 VGND VGND VPWR VPWR sky130_fd_sc_hd__decap_3
X_622_ _622_/A _622_/B _622_/C VGND VGND VPWR VPWR _623_/B sky130_fd_sc_hd__nand3_2
XFILLER_16_60 VGND VGND VPWR VPWR sky130_fd_sc_hd__fill_1
X_553_ _664_/A _554_/B VGND VGND VPWR VPWR _556_/A sky130_fd_sc_hd__nor2_2
X_484_ _476_/Y _473_/X _460_/Y _458_/X VGND VGND VPWR VPWR _484_/X sky130_fd_sc_hd__o22a_2
XTAP_TAPCELL_ROW_14_125 VGND VPWR sky130_fd_sc_hd__tapvpwrvgnd_1
XFILLER_12_141 VGND VGND VPWR VPWR sky130_fd_sc_hd__decap_3
XFILLER_12_174 VGND VGND VPWR VPWR sky130_fd_sc_hd__decap_3
XFILLER_8_178 VGND VGND VPWR VPWR sky130_fd_sc_hd__decap_3
XFILLER_8_156 VGND VGND VPWR VPWR sky130_fd_sc_hd__fill_2
XFILLER_35_200 VGND VGND VPWR VPWR sky130_fd_sc_hd__decap_3
XFILLER_12_29 VGND VGND VPWR VPWR sky130_fd_sc_hd__fill_2
XFILLER_5_137 VGND VGND VPWR VPWR sky130_fd_sc_hd__decap_3
XFILLER_5_148 VGND VGND VPWR VPWR sky130_fd_sc_hd__decap_3
X_605_ _605_/A _605_/B _605_/C _605_/D VGND VGND VPWR VPWR _605_/Y sky130_fd_sc_hd__nand4_4
X_536_ _546_/A _533_/B _535_/Y VGND VGND VPWR VPWR _536_/X sky130_fd_sc_hd__a21o_2
X_467_ _452_/A _452_/B _440_/B VGND VGND VPWR VPWR _467_/Y sky130_fd_sc_hd__o21ai_2
X_398_ _395_/X _397_/Y _622_/A VGND VGND VPWR VPWR _620_/A sky130_fd_sc_hd__o21a_2
XFILLER_32_203 VGND VGND VPWR VPWR sky130_fd_sc_hd__decap_3
XFILLER_4_63 VGND VGND VPWR VPWR sky130_fd_sc_hd__decap_3
XFILLER_4_181 VGND VGND VPWR VPWR sky130_fd_sc_hd__decap_3
XFILLER_23_39 VGND VGND VPWR VPWR sky130_fd_sc_hd__decap_3
XFILLER_13_50 VGND VGND VPWR VPWR sky130_fd_sc_hd__decap_3
XFILLER_13_72 VGND VGND VPWR VPWR sky130_fd_sc_hd__decap_3
XTAP_TAPCELL_ROW_0_75 VGND VPWR sky130_fd_sc_hd__tapvpwrvgnd_1
X_519_ _519_/A _519_/B VGND VGND VPWR VPWR _573_/B sky130_fd_sc_hd__nand2_2
XFILLER_34_27 VGND VGND VPWR VPWR sky130_fd_sc_hd__fill_1
XFILLER_1_6 VGND VGND VPWR VPWR sky130_fd_sc_hd__decap_3
XFILLER_6_210 VGND VGND VPWR VPWR sky130_fd_sc_hd__fill_1
XFILLER_24_82 VGND VGND VPWR VPWR sky130_fd_sc_hd__fill_2
XFILLER_20_29 VGND VGND VPWR VPWR sky130_fd_sc_hd__decap_3
XFILLER_29_16 VGND VGND VPWR VPWR sky130_fd_sc_hd__decap_3
XFILLER_10_51 VGND VGND VPWR VPWR sky130_fd_sc_hd__decap_3
XFILLER_19_147 VGND VGND VPWR VPWR sky130_fd_sc_hd__decap_3
XFILLER_19_169 VGND VGND VPWR VPWR sky130_fd_sc_hd__decap_3
XTAP_TAPCELL_ROW_6_96 VGND VPWR sky130_fd_sc_hd__tapvpwrvgnd_1
XFILLER_16_106 VGND VGND VPWR VPWR sky130_fd_sc_hd__decap_3
XFILLER_16_139 VGND VGND VPWR VPWR sky130_fd_sc_hd__fill_1
XTAP_TAPCELL_ROW_26_167 VGND VPWR sky130_fd_sc_hd__tapvpwrvgnd_1
XFILLER_24_150 VGND VGND VPWR VPWR sky130_fd_sc_hd__decap_3
XFILLER_24_183 VGND VGND VPWR VPWR sky130_fd_sc_hd__decap_3
XFILLER_21_94 VGND VGND VPWR VPWR sky130_fd_sc_hd__decap_3
XFILLER_21_83 VGND VGND VPWR VPWR sky130_fd_sc_hd__fill_2
XFILLER_15_161 VGND VGND VPWR VPWR sky130_fd_sc_hd__decap_3
X_698_ _717_/A _695_/B input32/X VGND VGND VPWR VPWR _698_/Y sky130_fd_sc_hd__a21boi_2
XFILLER_22_109 VGND VGND VPWR VPWR sky130_fd_sc_hd__decap_3
XFILLER_30_175 VGND VGND VPWR VPWR sky130_fd_sc_hd__fill_2
XFILLER_21_164 VGND VGND VPWR VPWR sky130_fd_sc_hd__decap_3
X_621_ _622_/A _622_/C _622_/B VGND VGND VPWR VPWR _621_/Y sky130_fd_sc_hd__a21oi_2
XFILLER_16_83 VGND VGND VPWR VPWR sky130_fd_sc_hd__fill_1
X_552_ _552_/A _552_/B VGND VGND VPWR VPWR _552_/Y sky130_fd_sc_hd__nand2_2
X_483_ _473_/X _476_/Y _475_/Y _471_/A VGND VGND VPWR VPWR _506_/A sky130_fd_sc_hd__o211a_2
XTAP_TAPCELL_ROW_14_126 VGND VPWR sky130_fd_sc_hd__tapvpwrvgnd_1
XFILLER_8_102 VGND VGND VPWR VPWR sky130_fd_sc_hd__decap_3
XTAP_TAPCELL_ROW_3_86 VGND VPWR sky130_fd_sc_hd__tapvpwrvgnd_1
XFILLER_7_190 VGND VGND VPWR VPWR sky130_fd_sc_hd__decap_3
XFILLER_5_116 VGND VGND VPWR VPWR sky130_fd_sc_hd__decap_3
X_535_ _533_/A _533_/B _535_/B1 VGND VGND VPWR VPWR _535_/Y sky130_fd_sc_hd__o21ai_2
X_604_ _601_/Y _603_/X _602_/Y VGND VGND VPWR VPWR _604_/Y sky130_fd_sc_hd__o21ai_4
XFILLER_27_60 VGND VGND VPWR VPWR sky130_fd_sc_hd__decap_3
X_466_ _466_/A _466_/B VGND VGND VPWR VPWR _466_/X sky130_fd_sc_hd__and2_2
X_397_ _426_/A _395_/B _397_/B1 VGND VGND VPWR VPWR _397_/Y sky130_fd_sc_hd__o21ai_4
XFILLER_4_193 VGND VGND VPWR VPWR sky130_fd_sc_hd__decap_3
XFILLER_13_84 VGND VGND VPWR VPWR sky130_fd_sc_hd__decap_3
XTAP_TAPCELL_ROW_0_76 VGND VPWR sky130_fd_sc_hd__tapvpwrvgnd_1
X_518_ _519_/B _519_/A VGND VGND VPWR VPWR _518_/X sky130_fd_sc_hd__and2_4
X_449_ _473_/A _449_/B VGND VGND VPWR VPWR _450_/B sky130_fd_sc_hd__and2_2
XFILLER_20_207 VGND VGND VPWR VPWR sky130_fd_sc_hd__decap_3
XFILLER_10_63 VGND VGND VPWR VPWR sky130_fd_sc_hd__decap_3
XFILLER_10_85 VGND VGND VPWR VPWR sky130_fd_sc_hd__decap_3
XFILLER_19_83 VGND VGND VPWR VPWR sky130_fd_sc_hd__fill_1
XFILLER_19_50 VGND VGND VPWR VPWR sky130_fd_sc_hd__decap_3
XTAP_TAPCELL_ROW_6_97 VGND VPWR sky130_fd_sc_hd__tapvpwrvgnd_1
XPHY_EDGE_ROW_27_Left_63 VGND VGND VPWR VPWR sky130_fd_sc_hd__decap_3
XPHY_EDGE_ROW_11_Left_47 VGND VGND VPWR VPWR sky130_fd_sc_hd__decap_3
XFILLER_25_107 VGND VGND VPWR VPWR sky130_fd_sc_hd__decap_3
XFILLER_0_206 VGND VGND VPWR VPWR sky130_fd_sc_hd__decap_3
XFILLER_16_118 VGND VGND VPWR VPWR sky130_fd_sc_hd__decap_3
XTAP_TAPCELL_ROW_26_168 VGND VPWR sky130_fd_sc_hd__tapvpwrvgnd_1
XFILLER_24_162 VGND VGND VPWR VPWR sky130_fd_sc_hd__decap_3
X_697_ _694_/Y _695_/X input32/X VGND VGND VPWR VPWR _709_/A sky130_fd_sc_hd__o21bai_4
XTAP_TAPCELL_ROW_17_135 VGND VPWR sky130_fd_sc_hd__tapvpwrvgnd_1
XFILLER_15_140 VGND VGND VPWR VPWR sky130_fd_sc_hd__decap_3
XFILLER_7_97 VGND VGND VPWR VPWR sky130_fd_sc_hd__decap_3
XFILLER_7_53 VGND VGND VPWR VPWR sky130_fd_sc_hd__decap_3
XFILLER_7_31 VGND VGND VPWR VPWR sky130_fd_sc_hd__fill_1
XPHY_EDGE_ROW_5_Right_5 VGND VGND VPWR VPWR sky130_fd_sc_hd__decap_3
XFILLER_26_29 VGND VGND VPWR VPWR sky130_fd_sc_hd__decap_3
XTAP_TAPCELL_ROW_8_103 VGND VPWR sky130_fd_sc_hd__tapvpwrvgnd_1
X_551_ _542_/Y _551_/B _571_/B VGND VGND VPWR VPWR _552_/B sky130_fd_sc_hd__nand3b_4
X_620_ _620_/A _620_/B VGND VGND VPWR VPWR _620_/X sky130_fd_sc_hd__xor2_2
X_482_ _482_/A _482_/B VGND VGND VPWR VPWR _482_/Y sky130_fd_sc_hd__nand2_4
XTAP_TAPCELL_ROW_14_127 VGND VPWR sky130_fd_sc_hd__tapvpwrvgnd_1
XFILLER_8_125 VGND VGND VPWR VPWR sky130_fd_sc_hd__decap_3
XTAP_TAPCELL_ROW_3_87 VGND VPWR sky130_fd_sc_hd__tapvpwrvgnd_1
XFILLER_8_147 VGND VGND VPWR VPWR sky130_fd_sc_hd__decap_3
XFILLER_32_61 VGND VGND VPWR VPWR sky130_fd_sc_hd__decap_3
XPHY_EDGE_ROW_14_Left_50 VGND VGND VPWR VPWR sky130_fd_sc_hd__decap_3
Xrebuffer211 rebuffer212/X VGND VGND VPWR VPWR rebuffer211/X sky130_fd_sc_hd__buf_6
X_534_ _532_/Y _533_/X _535_/B1 VGND VGND VPWR VPWR _534_/X sky130_fd_sc_hd__o21ba_2
X_603_ _605_/A _605_/D _596_/Y VGND VGND VPWR VPWR _603_/X sky130_fd_sc_hd__a21o_2
X_465_ _519_/B VGND VGND VPWR VPWR _465_/Y sky130_fd_sc_hd__inv_2
XFILLER_27_72 VGND VGND VPWR VPWR sky130_fd_sc_hd__decap_3
XFILLER_27_50 VGND VGND VPWR VPWR sky130_fd_sc_hd__decap_3
X_396_ _395_/X _394_/Y _397_/B1 VGND VGND VPWR VPWR _418_/A sky130_fd_sc_hd__o21bai_4
XFILLER_4_172 VGND VGND VPWR VPWR sky130_fd_sc_hd__decap_3
XFILLER_4_150 VGND VGND VPWR VPWR sky130_fd_sc_hd__decap_3
XFILLER_4_98 VGND VGND VPWR VPWR sky130_fd_sc_hd__decap_3
XFILLER_13_63 VGND VGND VPWR VPWR sky130_fd_sc_hd__decap_3
XFILLER_13_96 VGND VGND VPWR VPWR sky130_fd_sc_hd__decap_3
XFILLER_1_120 VGND VGND VPWR VPWR sky130_fd_sc_hd__fill_2
XTAP_TAPCELL_ROW_0_77 VGND VPWR sky130_fd_sc_hd__tapvpwrvgnd_1
XFILLER_1_164 VGND VGND VPWR VPWR sky130_fd_sc_hd__decap_3
X_517_ _519_/A _469_/Y _516_/Y VGND VGND VPWR VPWR _517_/Y sky130_fd_sc_hd__a21oi_2
X_448_ _473_/A _449_/B VGND VGND VPWR VPWR _450_/A sky130_fd_sc_hd__nor2_2
X_379_ _382_/B _728_/A VGND VGND VPWR VPWR _385_/B sky130_fd_sc_hd__nand2b_4
XFILLER_34_18 VGND VGND VPWR VPWR sky130_fd_sc_hd__decap_3
XFILLER_34_29 VGND VGND VPWR VPWR sky130_fd_sc_hd__fill_1
XFILLER_28_138 VGND VGND VPWR VPWR sky130_fd_sc_hd__fill_2
XFILLER_10_75 VGND VGND VPWR VPWR sky130_fd_sc_hd__decap_3
XFILLER_10_97 VGND VGND VPWR VPWR sky130_fd_sc_hd__decap_3
XFILLER_3_204 VGND VGND VPWR VPWR sky130_fd_sc_hd__decap_3
XTAP_TAPCELL_ROW_29_177 VGND VPWR sky130_fd_sc_hd__tapvpwrvgnd_1
XFILLER_27_160 VGND VGND VPWR VPWR sky130_fd_sc_hd__decap_3
XTAP_TAPCELL_ROW_6_98 VGND VPWR sky130_fd_sc_hd__tapvpwrvgnd_1
XFILLER_18_3 VGND VGND VPWR VPWR sky130_fd_sc_hd__decap_3
XFILLER_33_196 VGND VGND VPWR VPWR sky130_fd_sc_hd__decap_3
XTAP_TAPCELL_ROW_26_169 VGND VPWR sky130_fd_sc_hd__tapvpwrvgnd_1
XFILLER_24_174 VGND VGND VPWR VPWR sky130_fd_sc_hd__decap_3
XFILLER_24_141 VGND VGND VPWR VPWR sky130_fd_sc_hd__decap_3
XFILLER_21_52 VGND VGND VPWR VPWR sky130_fd_sc_hd__decap_3
XFILLER_21_30 VGND VGND VPWR VPWR sky130_fd_sc_hd__fill_1
XFILLER_15_152 VGND VGND VPWR VPWR sky130_fd_sc_hd__decap_3
X_696_ _694_/Y _695_/X input32/X VGND VGND VPWR VPWR _696_/X sky130_fd_sc_hd__o21ba_2
XTAP_TAPCELL_ROW_17_136 VGND VPWR sky130_fd_sc_hd__tapvpwrvgnd_1
XFILLER_15_185 VGND VGND VPWR VPWR sky130_fd_sc_hd__fill_2
XFILLER_30_188 VGND VGND VPWR VPWR sky130_fd_sc_hd__fill_1
XFILLER_30_166 VGND VGND VPWR VPWR sky130_fd_sc_hd__decap_3
XFILLER_30_144 VGND VGND VPWR VPWR sky130_fd_sc_hd__decap_3
XFILLER_30_122 VGND VGND VPWR VPWR sky130_fd_sc_hd__decap_3
XFILLER_30_100 VGND VGND VPWR VPWR sky130_fd_sc_hd__fill_2
XFILLER_21_100 VGND VGND VPWR VPWR sky130_fd_sc_hd__decap_3
XTAP_TAPCELL_ROW_8_104 VGND VPWR sky130_fd_sc_hd__tapvpwrvgnd_1
X_550_ _542_/Y _544_/A _571_/B VGND VGND VPWR VPWR _552_/A sky130_fd_sc_hd__o21bai_2
X_481_ _474_/X _477_/Y _479_/Y VGND VGND VPWR VPWR _482_/A sky130_fd_sc_hd__o21ai_2
XFILLER_12_100 VGND VGND VPWR VPWR sky130_fd_sc_hd__decap_3
XFILLER_12_144 VGND VGND VPWR VPWR sky130_fd_sc_hd__decap_3
XFILLER_12_177 VGND VGND VPWR VPWR sky130_fd_sc_hd__fill_1
XFILLER_16_85 VGND VGND VPWR VPWR sky130_fd_sc_hd__decap_3
XPHY_EDGE_ROW_11_Right_11 VGND VGND VPWR VPWR sky130_fd_sc_hd__decap_3
XTAP_TAPCELL_ROW_3_88 VGND VPWR sky130_fd_sc_hd__tapvpwrvgnd_1
XPHY_EDGE_ROW_20_Right_20 VGND VGND VPWR VPWR sky130_fd_sc_hd__decap_3
XFILLER_32_95 VGND VGND VPWR VPWR sky130_fd_sc_hd__fill_1
XFILLER_35_203 VGND VGND VPWR VPWR sky130_fd_sc_hd__decap_3
X_679_ _665_/A _666_/Y _691_/B _677_/Y VGND VGND VPWR VPWR _679_/Y sky130_fd_sc_hd__o211ai_2
Xrebuffer212 _393_/B VGND VGND VPWR VPWR rebuffer212/X sky130_fd_sc_hd__buf_6
Xrebuffer201 rebuffer211/X VGND VGND VPWR VPWR _617_/A sky130_fd_sc_hd__buf_6
X_602_ _598_/Y _601_/Y _596_/Y VGND VGND VPWR VPWR _602_/Y sky130_fd_sc_hd__o21ai_2
X_533_ _533_/A _533_/B VGND VGND VPWR VPWR _533_/X sky130_fd_sc_hd__and2_4
X_464_ _659_/Y _464_/B _464_/C _464_/D VGND VGND VPWR VPWR _519_/B sky130_fd_sc_hd__nor4_4
XFILLER_32_206 VGND VGND VPWR VPWR sky130_fd_sc_hd__decap_3
X_395_ _426_/A _395_/B VGND VGND VPWR VPWR _395_/X sky130_fd_sc_hd__and2_4
XFILLER_4_66 VGND VGND VPWR VPWR sky130_fd_sc_hd__decap_3
XFILLER_4_184 VGND VGND VPWR VPWR sky130_fd_sc_hd__decap_3
XFILLER_4_11 VGND VGND VPWR VPWR sky130_fd_sc_hd__decap_3
XFILLER_13_53 VGND VGND VPWR VPWR sky130_fd_sc_hd__decap_3
XFILLER_13_75 VGND VGND VPWR VPWR sky130_fd_sc_hd__decap_3
XTAP_TAPCELL_ROW_0_78 VGND VPWR sky130_fd_sc_hd__tapvpwrvgnd_1
X_516_ _506_/B _503_/X _508_/Y _500_/X VGND VGND VPWR VPWR _516_/Y sky130_fd_sc_hd__a31oi_2
X_447_ _464_/C _447_/B _693_/X _447_/D VGND VGND VPWR VPWR _456_/A sky130_fd_sc_hd__nand4b_2
X_378_ _378_/A _378_/B VGND VGND VPWR VPWR _378_/X sky130_fd_sc_hd__or2_4
XFILLER_9_210 VGND VGND VPWR VPWR sky130_fd_sc_hd__fill_1
XFILLER_1_9 VGND VGND VPWR VPWR sky130_fd_sc_hd__decap_3
XFILLER_24_85 VGND VGND VPWR VPWR sky130_fd_sc_hd__fill_2
XFILLER_24_74 VGND VGND VPWR VPWR sky130_fd_sc_hd__fill_1
XFILLER_1_12 VGND VGND VPWR VPWR sky130_fd_sc_hd__decap_3
XFILLER_1_67 VGND VGND VPWR VPWR sky130_fd_sc_hd__decap_3
XFILLER_10_54 VGND VGND VPWR VPWR sky130_fd_sc_hd__decap_3
XTAP_TAPCELL_ROW_29_178 VGND VPWR sky130_fd_sc_hd__tapvpwrvgnd_1
XFILLER_27_172 VGND VGND VPWR VPWR sky130_fd_sc_hd__decap_3
XFILLER_19_41 VGND VGND VPWR VPWR sky130_fd_sc_hd__decap_3
XTAP_TAPCELL_ROW_6_99 VGND VPWR sky130_fd_sc_hd__tapvpwrvgnd_1
XFILLER_16_109 VGND VGND VPWR VPWR sky130_fd_sc_hd__decap_3
XFILLER_24_197 VGND VGND VPWR VPWR sky130_fd_sc_hd__decap_3
XFILLER_24_186 VGND VGND VPWR VPWR sky130_fd_sc_hd__decap_3
XFILLER_24_153 VGND VGND VPWR VPWR sky130_fd_sc_hd__decap_3
XFILLER_21_97 VGND VGND VPWR VPWR sky130_fd_sc_hd__decap_3
XFILLER_15_131 VGND VGND VPWR VPWR sky130_fd_sc_hd__decap_3
XFILLER_15_164 VGND VGND VPWR VPWR sky130_fd_sc_hd__decap_3
X_695_ _717_/A _695_/B VGND VGND VPWR VPWR _695_/X sky130_fd_sc_hd__and2_4
XTAP_TAPCELL_ROW_17_137 VGND VPWR sky130_fd_sc_hd__tapvpwrvgnd_1
XFILLER_15_197 VGND VGND VPWR VPWR sky130_fd_sc_hd__decap_3
XFILLER_7_66 VGND VGND VPWR VPWR sky130_fd_sc_hd__decap_3
XFILLER_7_11 VGND VGND VPWR VPWR sky130_fd_sc_hd__fill_1
XFILLER_21_167 VGND VGND VPWR VPWR sky130_fd_sc_hd__fill_1
XTAP_TAPCELL_ROW_8_105 VGND VPWR sky130_fd_sc_hd__tapvpwrvgnd_1
XTAP_TAPCELL_ROW_31_184 VGND VPWR sky130_fd_sc_hd__tapvpwrvgnd_1
X_480_ _471_/B _471_/A _515_/A _515_/C VGND VGND VPWR VPWR _482_/B sky130_fd_sc_hd__a211o_4
XFILLER_12_112 VGND VGND VPWR VPWR sky130_fd_sc_hd__decap_3
XFILLER_8_105 VGND VGND VPWR VPWR sky130_fd_sc_hd__decap_3
XFILLER_32_85 VGND VGND VPWR VPWR sky130_fd_sc_hd__fill_2
X_678_ _665_/Y input6/X _676_/Y _691_/C VGND VGND VPWR VPWR _678_/Y sky130_fd_sc_hd__a22oi_2
Xrebuffer213 _728_/A VGND VGND VPWR VPWR _353_/A sky130_fd_sc_hd__buf_2
XFILLER_5_119 VGND VGND VPWR VPWR sky130_fd_sc_hd__fill_1
X_601_ _601_/A VGND VGND VPWR VPWR _601_/Y sky130_fd_sc_hd__inv_2
XFILLER_27_63 VGND VGND VPWR VPWR sky130_fd_sc_hd__decap_3
XFILLER_27_41 VGND VGND VPWR VPWR sky130_fd_sc_hd__decap_3
X_532_ _533_/A _533_/B VGND VGND VPWR VPWR _532_/Y sky130_fd_sc_hd__nor2_2
X_463_ _515_/A _515_/D VGND VGND VPWR VPWR _471_/A sky130_fd_sc_hd__nor2_2
X_394_ _426_/A _395_/B VGND VGND VPWR VPWR _394_/Y sky130_fd_sc_hd__nor2_2
XFILLER_27_96 VGND VGND VPWR VPWR sky130_fd_sc_hd__decap_3
XTAP_TAPCELL_ROW_10_110 VGND VPWR sky130_fd_sc_hd__tapvpwrvgnd_1
XFILLER_4_141 VGND VGND VPWR VPWR sky130_fd_sc_hd__decap_3
XFILLER_14_207 VGND VGND VPWR VPWR sky130_fd_sc_hd__decap_3
XFILLER_13_87 VGND VGND VPWR VPWR sky130_fd_sc_hd__decap_3
XFILLER_1_199 VGND VGND VPWR VPWR sky130_fd_sc_hd__decap_3
X_515_ _515_/A _515_/B _515_/C _515_/D VGND VGND VPWR VPWR _519_/A sky130_fd_sc_hd__nor4_4
X_446_ _443_/X _440_/B _440_/A VGND VGND VPWR VPWR _466_/A sky130_fd_sc_hd__a21boi_2
X_377_ _378_/B _378_/A VGND VGND VPWR VPWR _420_/B sky130_fd_sc_hd__nor2_4
X_429_ _426_/Y _429_/B _429_/C VGND VGND VPWR VPWR _442_/B sky130_fd_sc_hd__nand3b_2
Xinput1 A[0] VGND VGND VPWR VPWR _615_/A sky130_fd_sc_hd__clkdlybuf4s25_1
XFILLER_10_11 VGND VGND VPWR VPWR sky130_fd_sc_hd__fill_2
XFILLER_10_66 VGND VGND VPWR VPWR sky130_fd_sc_hd__decap_3
XFILLER_10_88 VGND VGND VPWR VPWR sky130_fd_sc_hd__decap_3
XFILLER_19_53 VGND VGND VPWR VPWR sky130_fd_sc_hd__decap_3
XFILLER_19_31 VGND VGND VPWR VPWR sky130_fd_sc_hd__decap_3
XTAP_TAPCELL_ROW_29_179 VGND VPWR sky130_fd_sc_hd__tapvpwrvgnd_1
XFILLER_35_85 VGND VGND VPWR VPWR sky130_fd_sc_hd__decap_3
XFILLER_27_184 VGND VGND VPWR VPWR sky130_fd_sc_hd__fill_1
XFILLER_33_165 VGND VGND VPWR VPWR sky130_fd_sc_hd__decap_3
XFILLER_33_110 VGND VGND VPWR VPWR sky130_fd_sc_hd__fill_2
XFILLER_18_173 VGND VGND VPWR VPWR sky130_fd_sc_hd__decap_3
XFILLER_0_209 VGND VGND VPWR VPWR sky130_fd_sc_hd__fill_2
XFILLER_24_165 VGND VGND VPWR VPWR sky130_fd_sc_hd__decap_3
X_694_ _717_/A _695_/B VGND VGND VPWR VPWR _694_/Y sky130_fd_sc_hd__nor2_2
XFILLER_15_143 VGND VGND VPWR VPWR sky130_fd_sc_hd__decap_3
XFILLER_30_113 VGND VGND VPWR VPWR sky130_fd_sc_hd__fill_2
XFILLER_7_45 VGND VGND VPWR VPWR sky130_fd_sc_hd__decap_3
XFILLER_30_157 VGND VGND VPWR VPWR sky130_fd_sc_hd__decap_3
XTAP_TAPCELL_ROW_31_185 VGND VPWR sky130_fd_sc_hd__tapvpwrvgnd_1
XFILLER_21_113 VGND VGND VPWR VPWR sky130_fd_sc_hd__decap_3
XTAP_TAPCELL_ROW_8_106 VGND VPWR sky130_fd_sc_hd__tapvpwrvgnd_1
XFILLER_16_32 VGND VGND VPWR VPWR sky130_fd_sc_hd__decap_3
XTAP_TAPCELL_ROW_22_152 VGND VPWR sky130_fd_sc_hd__tapvpwrvgnd_1
XFILLER_8_128 VGND VGND VPWR VPWR sky130_fd_sc_hd__decap_3
X_677_ _691_/C _677_/B _677_/C VGND VGND VPWR VPWR _677_/Y sky130_fd_sc_hd__nand3_2
XPHY_EDGE_ROW_9_Right_9 VGND VGND VPWR VPWR sky130_fd_sc_hd__decap_3
XFILLER_5_109 VGND VGND VPWR VPWR sky130_fd_sc_hd__decap_3
X_531_ _538_/B _531_/B VGND VGND VPWR VPWR _531_/X sky130_fd_sc_hd__and2_2
X_600_ _585_/X _597_/B _597_/C VGND VGND VPWR VPWR _601_/A sky130_fd_sc_hd__o21a_2
XFILLER_27_75 VGND VGND VPWR VPWR sky130_fd_sc_hd__decap_3
XFILLER_27_53 VGND VGND VPWR VPWR sky130_fd_sc_hd__decap_3
XFILLER_27_20 VGND VGND VPWR VPWR sky130_fd_sc_hd__decap_3
X_462_ _458_/X _459_/Y _460_/B1 VGND VGND VPWR VPWR _515_/D sky130_fd_sc_hd__o21ba_2
X_393_ _393_/A _393_/B VGND VGND VPWR VPWR _410_/C sky130_fd_sc_hd__nor2_4
XTAP_TAPCELL_ROW_10_111 VGND VPWR sky130_fd_sc_hd__tapvpwrvgnd_1
XFILLER_4_175 VGND VGND VPWR VPWR sky130_fd_sc_hd__decap_3
XFILLER_4_153 VGND VGND VPWR VPWR sky130_fd_sc_hd__decap_3
XFILLER_4_197 VGND VGND VPWR VPWR sky130_fd_sc_hd__decap_3
X_729_ _730_/B1 _729_/B _729_/C VGND VGND VPWR VPWR _729_/Y sky130_fd_sc_hd__nand3b_2
XPHY_EDGE_ROW_18_Left_54 VGND VGND VPWR VPWR sky130_fd_sc_hd__decap_3
XFILLER_13_11 VGND VGND VPWR VPWR sky130_fd_sc_hd__fill_1
XFILLER_13_66 VGND VGND VPWR VPWR sky130_fd_sc_hd__decap_3
XFILLER_13_99 VGND VGND VPWR VPWR sky130_fd_sc_hd__decap_3
XFILLER_1_167 VGND VGND VPWR VPWR sky130_fd_sc_hd__fill_1
X_514_ _514_/A1 _502_/Y _491_/Y _501_/Y _493_/Y VGND VGND VPWR VPWR _515_/B sky130_fd_sc_hd__o2111ai_4
X_445_ _464_/C _445_/B VGND VGND VPWR VPWR _445_/X sky130_fd_sc_hd__xor2_2
X_376_ _406_/B _376_/B _411_/C _376_/D VGND VGND VPWR VPWR _378_/B sky130_fd_sc_hd__nand4b_4
XPHY_EDGE_ROW_3_Left_39 VGND VGND VPWR VPWR sky130_fd_sc_hd__decap_3
X_428_ _428_/A _428_/B VGND VGND VPWR VPWR _429_/B sky130_fd_sc_hd__nand2_2
X_359_ _353_/Y _354_/X _357_/Y _358_/B VGND VGND VPWR VPWR _627_/A sky130_fd_sc_hd__a22oi_4
Xinput2 A[10] VGND VGND VPWR VPWR input2/X sky130_fd_sc_hd__clkdlybuf4s25_1
XFILLER_28_119 VGND VGND VPWR VPWR sky130_fd_sc_hd__decap_3
XFILLER_28_108 VGND VGND VPWR VPWR sky130_fd_sc_hd__fill_1
XFILLER_10_45 VGND VGND VPWR VPWR sky130_fd_sc_hd__decap_3
XFILLER_10_78 VGND VGND VPWR VPWR sky130_fd_sc_hd__decap_3
XFILLER_3_207 VGND VGND VPWR VPWR sky130_fd_sc_hd__decap_3
XFILLER_35_97 VGND VGND VPWR VPWR sky130_fd_sc_hd__fill_1
XFILLER_27_163 VGND VGND VPWR VPWR sky130_fd_sc_hd__decap_3
XFILLER_27_141 VGND VGND VPWR VPWR sky130_fd_sc_hd__fill_1
XFILLER_18_141 VGND VGND VPWR VPWR sky130_fd_sc_hd__decap_3
XFILLER_33_199 VGND VGND VPWR VPWR sky130_fd_sc_hd__decap_3
XFILLER_24_177 VGND VGND VPWR VPWR sky130_fd_sc_hd__decap_3
XFILLER_24_144 VGND VGND VPWR VPWR sky130_fd_sc_hd__decap_3
XFILLER_24_111 VGND VGND VPWR VPWR sky130_fd_sc_hd__decap_3
XTAP_TAPCELL_ROW_34_194 VGND VPWR sky130_fd_sc_hd__tapvpwrvgnd_1
XFILLER_21_55 VGND VGND VPWR VPWR sky130_fd_sc_hd__fill_1
XFILLER_21_77 VGND VGND VPWR VPWR sky130_fd_sc_hd__decap_3
XFILLER_15_100 VGND VGND VPWR VPWR sky130_fd_sc_hd__decap_3
X_693_ _691_/X _692_/B _692_/A _688_/X _685_/Y VGND VGND VPWR VPWR _693_/X sky130_fd_sc_hd__a41o_2
XPHY_EDGE_ROW_6_Left_42 VGND VGND VPWR VPWR sky130_fd_sc_hd__decap_3
XFILLER_15_122 VGND VGND VPWR VPWR sky130_fd_sc_hd__decap_3
XFILLER_15_155 VGND VGND VPWR VPWR sky130_fd_sc_hd__decap_3
XFILLER_30_169 VGND VGND VPWR VPWR sky130_fd_sc_hd__decap_3
XFILLER_30_147 VGND VGND VPWR VPWR sky130_fd_sc_hd__decap_3
XFILLER_30_125 VGND VGND VPWR VPWR sky130_fd_sc_hd__fill_1
XFILLER_7_57 VGND VGND VPWR VPWR sky130_fd_sc_hd__decap_3
XFILLER_21_103 VGND VGND VPWR VPWR sky130_fd_sc_hd__decap_3
XTAP_TAPCELL_ROW_31_186 VGND VPWR sky130_fd_sc_hd__tapvpwrvgnd_1
XFILLER_21_169 VGND VGND VPWR VPWR sky130_fd_sc_hd__decap_3
XFILLER_21_158 VGND VGND VPWR VPWR sky130_fd_sc_hd__decap_3
Xinput60 B[5] VGND VGND VPWR VPWR _353_/B sky130_fd_sc_hd__clkdlybuf4s25_1
XFILLER_12_103 VGND VGND VPWR VPWR sky130_fd_sc_hd__decap_3
XFILLER_12_147 VGND VGND VPWR VPWR sky130_fd_sc_hd__decap_3
XFILLER_16_77 VGND VGND VPWR VPWR sky130_fd_sc_hd__decap_3
XFILLER_16_88 VGND VGND VPWR VPWR sky130_fd_sc_hd__decap_3
XPHY_EDGE_ROW_32_Left_68 VGND VGND VPWR VPWR sky130_fd_sc_hd__decap_3
XTAP_TAPCELL_ROW_22_153 VGND VPWR sky130_fd_sc_hd__tapvpwrvgnd_1
XFILLER_32_32 VGND VGND VPWR VPWR sky130_fd_sc_hd__fill_1
XFILLER_20_180 VGND VGND VPWR VPWR sky130_fd_sc_hd__decap_3
X_676_ _674_/B _675_/Y _691_/B VGND VGND VPWR VPWR _676_/Y sky130_fd_sc_hd__o21ai_2
XFILLER_35_206 VGND VGND VPWR VPWR sky130_fd_sc_hd__decap_3
X_530_ _530_/A1 _530_/A2 _558_/A _559_/A2 VGND VGND VPWR VPWR _531_/B sky130_fd_sc_hd__o211ai_2
X_461_ _592_/A _459_/B _460_/Y VGND VGND VPWR VPWR _515_/A sky130_fd_sc_hd__a21oi_2
XFILLER_32_209 VGND VGND VPWR VPWR sky130_fd_sc_hd__fill_2
XFILLER_27_32 VGND VGND VPWR VPWR sky130_fd_sc_hd__decap_3
X_392_ _616_/S _389_/Y _388_/A _391_/Y VGND VGND VPWR VPWR _393_/A sky130_fd_sc_hd__o211ai_2
XTAP_TAPCELL_ROW_10_112 VGND VPWR sky130_fd_sc_hd__tapvpwrvgnd_1
XFILLER_4_187 VGND VGND VPWR VPWR sky130_fd_sc_hd__decap_3
XFILLER_4_14 VGND VGND VPWR VPWR sky130_fd_sc_hd__fill_1
XFILLER_4_69 VGND VGND VPWR VPWR sky130_fd_sc_hd__decap_3
X_659_ _659_/A _659_/B VGND VGND VPWR VPWR _659_/Y sky130_fd_sc_hd__nand2_2
X_728_ _728_/A _728_/B VGND VGND VPWR VPWR _728_/X sky130_fd_sc_hd__and2_2
XTAP_TAPCELL_ROW_4_90 VGND VPWR sky130_fd_sc_hd__tapvpwrvgnd_1
XFILLER_13_78 VGND VGND VPWR VPWR sky130_fd_sc_hd__decap_3
X_513_ _513_/A _513_/B VGND VGND VPWR VPWR _513_/Y sky130_fd_sc_hd__nor2_4
X_444_ _693_/X _447_/D _447_/B _443_/X VGND VGND VPWR VPWR _445_/B sky130_fd_sc_hd__a31oi_4
X_375_ _369_/Y _373_/X _411_/C VGND VGND VPWR VPWR _631_/A sky130_fd_sc_hd__o21ai_2
XPHY_EDGE_ROW_35_Left_71 VGND VGND VPWR VPWR sky130_fd_sc_hd__decap_3
XFILLER_24_55 VGND VGND VPWR VPWR sky130_fd_sc_hd__decap_3
XFILLER_1_15 VGND VGND VPWR VPWR sky130_fd_sc_hd__decap_3
X_427_ _428_/A _428_/B VGND VGND VPWR VPWR _427_/X sky130_fd_sc_hd__and2_4
X_358_ _653_/Y _358_/B _358_/C VGND VGND VPWR VPWR _358_/Y sky130_fd_sc_hd__nand3_4
XTAP_TAPCELL_ROW_1_80 VGND VPWR sky130_fd_sc_hd__tapvpwrvgnd_1
XPHY_EDGE_ROW_18_Right_18 VGND VGND VPWR VPWR sky130_fd_sc_hd__decap_3
Xinput3 A[11] VGND VGND VPWR VPWR input3/X sky130_fd_sc_hd__clkdlybuf4s25_1
XPHY_EDGE_ROW_27_Right_27 VGND VGND VPWR VPWR sky130_fd_sc_hd__decap_3
XFILLER_10_57 VGND VGND VPWR VPWR sky130_fd_sc_hd__decap_3
XFILLER_27_120 VGND VGND VPWR VPWR sky130_fd_sc_hd__decap_3
XFILLER_19_44 VGND VGND VPWR VPWR sky130_fd_sc_hd__decap_3
XFILLER_35_32 VGND VGND VPWR VPWR sky130_fd_sc_hd__decap_3
XFILLER_35_21 VGND VGND VPWR VPWR sky130_fd_sc_hd__decap_3
XFILLER_27_175 VGND VGND VPWR VPWR sky130_fd_sc_hd__decap_3
XFILLER_33_145 VGND VGND VPWR VPWR sky130_fd_sc_hd__decap_3
XFILLER_2_91 VGND VGND VPWR VPWR sky130_fd_sc_hd__fill_2
XFILLER_24_156 VGND VGND VPWR VPWR sky130_fd_sc_hd__decap_3
XTAP_TAPCELL_ROW_34_195 VGND VPWR sky130_fd_sc_hd__tapvpwrvgnd_1
XFILLER_15_134 VGND VGND VPWR VPWR sky130_fd_sc_hd__decap_3
X_692_ _692_/A _692_/B _692_/C _692_/D VGND VGND VPWR VPWR _692_/X sky130_fd_sc_hd__and4_4
XFILLER_15_167 VGND VGND VPWR VPWR sky130_fd_sc_hd__fill_1
XFILLER_7_69 VGND VGND VPWR VPWR sky130_fd_sc_hd__decap_3
Xinput61 B[6] VGND VGND VPWR VPWR _728_/B sky130_fd_sc_hd__clkdlybuf4s25_1
Xinput50 B[25] VGND VGND VPWR VPWR _533_/B sky130_fd_sc_hd__clkdlybuf4s25_1
XTAP_TAPCELL_ROW_22_154 VGND VPWR sky130_fd_sc_hd__tapvpwrvgnd_1
XPHY_EDGE_ROW_0_Right_0 VGND VGND VPWR VPWR sky130_fd_sc_hd__decap_3
XFILLER_8_108 VGND VGND VPWR VPWR sky130_fd_sc_hd__decap_3
XFILLER_32_22 VGND VGND VPWR VPWR sky130_fd_sc_hd__decap_3
XFILLER_20_192 VGND VGND VPWR VPWR sky130_fd_sc_hd__decap_3
X_675_ _712_/A _673_/B _677_/C VGND VGND VPWR VPWR _675_/Y sky130_fd_sc_hd__o21ai_2
XFILLER_11_181 VGND VGND VPWR VPWR sky130_fd_sc_hd__decap_3
XTAP_TAPCELL_ROW_13_121 VGND VPWR sky130_fd_sc_hd__tapvpwrvgnd_1
XFILLER_7_163 VGND VGND VPWR VPWR sky130_fd_sc_hd__decap_3
X_460_ _606_/A _459_/B _460_/B1 VGND VGND VPWR VPWR _460_/Y sky130_fd_sc_hd__o21ai_4
X_391_ _387_/X _388_/Y _615_/A VGND VGND VPWR VPWR _391_/Y sky130_fd_sc_hd__o21bai_4
XFILLER_27_99 VGND VGND VPWR VPWR sky130_fd_sc_hd__decap_3
XFILLER_27_66 VGND VGND VPWR VPWR sky130_fd_sc_hd__decap_3
XFILLER_27_44 VGND VGND VPWR VPWR sky130_fd_sc_hd__decap_3
XTAP_TAPCELL_ROW_10_113 VGND VPWR sky130_fd_sc_hd__tapvpwrvgnd_1
XFILLER_4_48 VGND VGND VPWR VPWR sky130_fd_sc_hd__decap_3
XFILLER_4_144 VGND VGND VPWR VPWR sky130_fd_sc_hd__decap_3
X_727_ _727_/A _728_/B VGND VGND VPWR VPWR _729_/C sky130_fd_sc_hd__nand2_2
X_589_ _568_/Y _579_/Y _587_/Y VGND VGND VPWR VPWR _589_/Y sky130_fd_sc_hd__o21ai_2
X_658_ _654_/Y _655_/X _657_/C VGND VGND VPWR VPWR _659_/B sky130_fd_sc_hd__o21bai_4
XTAP_TAPCELL_ROW_4_91 VGND VPWR sky130_fd_sc_hd__tapvpwrvgnd_1
XFILLER_13_57 VGND VGND VPWR VPWR sky130_fd_sc_hd__decap_3
XFILLER_1_169 VGND VGND VPWR VPWR sky130_fd_sc_hd__decap_3
X_512_ _507_/Y _510_/X _505_/Y VGND VGND VPWR VPWR _513_/B sky130_fd_sc_hd__a21oi_2
X_443_ _443_/A _443_/B VGND VGND VPWR VPWR _443_/X sky130_fd_sc_hd__and2_2
X_374_ _652_/A _370_/B _372_/Y VGND VGND VPWR VPWR _376_/D sky130_fd_sc_hd__o21ai_2
XFILLER_0_191 VGND VGND VPWR VPWR sky130_fd_sc_hd__decap_3
XFILLER_5_80 VGND VGND VPWR VPWR sky130_fd_sc_hd__decap_3
XFILLER_24_34 VGND VGND VPWR VPWR sky130_fd_sc_hd__decap_3
X_426_ _426_/A _428_/B VGND VGND VPWR VPWR _426_/Y sky130_fd_sc_hd__nor2_4
X_357_ _727_/A _353_/B _653_/A VGND VGND VPWR VPWR _357_/Y sky130_fd_sc_hd__a21oi_2
Xinput4 A[12] VGND VGND VPWR VPWR _677_/C sky130_fd_sc_hd__clkdlybuf4s25_1
XTAP_TAPCELL_ROW_1_81 VGND VPWR sky130_fd_sc_hd__tapvpwrvgnd_1
XFILLER_10_69 VGND VGND VPWR VPWR sky130_fd_sc_hd__decap_3
XFILLER_27_132 VGND VGND VPWR VPWR sky130_fd_sc_hd__decap_3
XFILLER_33_113 VGND VGND VPWR VPWR sky130_fd_sc_hd__fill_1
XFILLER_18_176 VGND VGND VPWR VPWR sky130_fd_sc_hd__fill_1
XFILLER_18_121 VGND VGND VPWR VPWR sky130_fd_sc_hd__decap_3
X_409_ _409_/A _409_/B VGND VGND VPWR VPWR _411_/A sky130_fd_sc_hd__nand2_2
XTAP_TAPCELL_ROW_34_196 VGND VPWR sky130_fd_sc_hd__tapvpwrvgnd_1
XFILLER_24_168 VGND VGND VPWR VPWR sky130_fd_sc_hd__decap_3
XFILLER_21_57 VGND VGND VPWR VPWR sky130_fd_sc_hd__decap_3
XFILLER_15_113 VGND VGND VPWR VPWR sky130_fd_sc_hd__decap_3
XFILLER_15_146 VGND VGND VPWR VPWR sky130_fd_sc_hd__decap_3
X_691_ _692_/D _691_/B _691_/C VGND VGND VPWR VPWR _691_/X sky130_fd_sc_hd__and3_2
Xmax_cap99 _507_/A VGND VGND VPWR VPWR _471_/B sky130_fd_sc_hd__buf_6
XTAP_TAPCELL_ROW_25_163 VGND VPWR sky130_fd_sc_hd__tapvpwrvgnd_1
XFILLER_11_90 VGND VGND VPWR VPWR sky130_fd_sc_hd__decap_3
XFILLER_21_116 VGND VGND VPWR VPWR sky130_fd_sc_hd__decap_3
Xinput40 B[16] VGND VGND VPWR VPWR _656_/A sky130_fd_sc_hd__clkdlybuf4s25_1
Xinput62 B[7] VGND VGND VPWR VPWR _370_/B sky130_fd_sc_hd__clkdlybuf4s25_1
Xinput51 B[26] VGND VGND VPWR VPWR _546_/B sky130_fd_sc_hd__clkdlybuf4s25_1
XFILLER_16_35 VGND VGND VPWR VPWR sky130_fd_sc_hd__fill_2
XFILLER_16_57 VGND VGND VPWR VPWR sky130_fd_sc_hd__decap_3
XTAP_TAPCELL_ROW_22_155 VGND VPWR sky130_fd_sc_hd__tapvpwrvgnd_1
XFILLER_32_45 VGND VGND VPWR VPWR sky130_fd_sc_hd__decap_3
X_674_ _674_/A _674_/B VGND VGND VPWR VPWR _677_/B sky130_fd_sc_hd__nor2_2
XTAP_TAPCELL_ROW_13_122 VGND VPWR sky130_fd_sc_hd__tapvpwrvgnd_1
XFILLER_21_3 VGND VGND VPWR VPWR sky130_fd_sc_hd__decap_3
XFILLER_27_23 VGND VGND VPWR VPWR sky130_fd_sc_hd__decap_3
X_390_ _388_/A _616_/S _389_/Y VGND VGND VPWR VPWR _390_/Y sky130_fd_sc_hd__a21oi_2
XFILLER_27_78 VGND VGND VPWR VPWR sky130_fd_sc_hd__fill_1
XFILLER_4_27 VGND VGND VPWR VPWR sky130_fd_sc_hd__fill_1
XFILLER_4_178 VGND VGND VPWR VPWR sky130_fd_sc_hd__decap_3
XFILLER_4_156 VGND VGND VPWR VPWR sky130_fd_sc_hd__decap_3
XFILLER_4_134 VGND VGND VPWR VPWR sky130_fd_sc_hd__decap_3
X_657_ _654_/Y _657_/B _657_/C VGND VGND VPWR VPWR _659_/A sky130_fd_sc_hd__nand3b_2
X_726_ _728_/B _726_/B VGND VGND VPWR VPWR _729_/B sky130_fd_sc_hd__nand2b_4
X_588_ _570_/Y _578_/Y _587_/Y VGND VGND VPWR VPWR _588_/Y sky130_fd_sc_hd__o21bai_2
XTAP_TAPCELL_ROW_4_92 VGND VPWR sky130_fd_sc_hd__tapvpwrvgnd_1
XFILLER_13_47 VGND VGND VPWR VPWR sky130_fd_sc_hd__decap_3
XFILLER_13_69 VGND VGND VPWR VPWR sky130_fd_sc_hd__decap_3
X_511_ _511_/A1 _507_/B _509_/Y _504_/X VGND VGND VPWR VPWR _513_/A sky130_fd_sc_hd__a211oi_4
X_442_ _659_/A _442_/B VGND VGND VPWR VPWR _443_/B sky130_fd_sc_hd__nand2_2
X_373_ _726_/B _370_/B input30/X VGND VGND VPWR VPWR _373_/X sky130_fd_sc_hd__a21bo_2
XFILLER_0_181 VGND VGND VPWR VPWR sky130_fd_sc_hd__fill_2
X_709_ _709_/A _709_/B _709_/C _709_/D VGND VGND VPWR VPWR _725_/B sky130_fd_sc_hd__nand4_4
XFILLER_5_92 VGND VGND VPWR VPWR sky130_fd_sc_hd__decap_3
XFILLER_1_39 VGND VGND VPWR VPWR sky130_fd_sc_hd__fill_1
X_425_ _659_/Y _425_/B VGND VGND VPWR VPWR _425_/X sky130_fd_sc_hd__xor2_2
X_356_ _353_/B _351_/B _355_/Y VGND VGND VPWR VPWR _356_/Y sky130_fd_sc_hd__o21ai_4
Xinput5 A[13] VGND VGND VPWR VPWR _671_/C sky130_fd_sc_hd__clkdlybuf4s25_1
XFILLER_10_26 VGND VGND VPWR VPWR sky130_fd_sc_hd__fill_2
XFILLER_10_48 VGND VGND VPWR VPWR sky130_fd_sc_hd__decap_3
XFILLER_35_12 VGND VGND VPWR VPWR sky130_fd_sc_hd__decap_3
XFILLER_27_166 VGND VGND VPWR VPWR sky130_fd_sc_hd__fill_2
XFILLER_27_111 VGND VGND VPWR VPWR sky130_fd_sc_hd__fill_1
XFILLER_19_68 VGND VGND VPWR VPWR sky130_fd_sc_hd__fill_2
XFILLER_19_57 VGND VGND VPWR VPWR sky130_fd_sc_hd__fill_2
X_408_ _373_/X _369_/Y _729_/Y _407_/Y VGND VGND VPWR VPWR _409_/A sky130_fd_sc_hd__a2bb2oi_2
XFILLER_33_169 VGND VGND VPWR VPWR sky130_fd_sc_hd__decap_3
XFILLER_18_144 VGND VGND VPWR VPWR sky130_fd_sc_hd__decap_3
XFILLER_24_114 VGND VGND VPWR VPWR sky130_fd_sc_hd__decap_3
XTAP_TAPCELL_ROW_34_197 VGND VPWR sky130_fd_sc_hd__tapvpwrvgnd_1
XFILLER_24_147 VGND VGND VPWR VPWR sky130_fd_sc_hd__decap_3
X_690_ _666_/Y _665_/A _691_/B _691_/C _680_/Y VGND VGND VPWR VPWR _692_/C sky130_fd_sc_hd__o2111a_2
XFILLER_15_103 VGND VGND VPWR VPWR sky130_fd_sc_hd__decap_3
XFILLER_15_125 VGND VGND VPWR VPWR sky130_fd_sc_hd__decap_3
XFILLER_15_158 VGND VGND VPWR VPWR sky130_fd_sc_hd__decap_3
XFILLER_15_169 VGND VGND VPWR VPWR sky130_fd_sc_hd__fill_1
XTAP_TAPCELL_ROW_25_164 VGND VPWR sky130_fd_sc_hd__tapvpwrvgnd_1
XFILLER_30_139 VGND VGND VPWR VPWR sky130_fd_sc_hd__fill_1
XTAP_TAPCELL_ROW_16_131 VGND VPWR sky130_fd_sc_hd__tapvpwrvgnd_1
XFILLER_21_106 VGND VGND VPWR VPWR sky130_fd_sc_hd__decap_3
Xinput30 A[7] VGND VGND VPWR VPWR input30/X sky130_fd_sc_hd__clkdlybuf4s25_1
Xinput41 B[17] VGND VGND VPWR VPWR _428_/B sky130_fd_sc_hd__clkdlybuf4s25_1
Xinput63 B[8] VGND VGND VPWR VPWR _702_/B sky130_fd_sc_hd__clkdlybuf4s25_1
Xinput52 B[27] VGND VGND VPWR VPWR _554_/B sky130_fd_sc_hd__clkdlybuf4s25_1
XFILLER_12_106 VGND VGND VPWR VPWR sky130_fd_sc_hd__decap_3
XFILLER_12_139 VGND VGND VPWR VPWR sky130_fd_sc_hd__fill_1
XFILLER_20_183 VGND VGND VPWR VPWR sky130_fd_sc_hd__decap_3
XFILLER_20_150 VGND VGND VPWR VPWR sky130_fd_sc_hd__fill_1
X_673_ _712_/A _673_/B VGND VGND VPWR VPWR _674_/B sky130_fd_sc_hd__and2_2
XFILLER_35_209 VGND VGND VPWR VPWR sky130_fd_sc_hd__fill_2
XFILLER_11_150 VGND VGND VPWR VPWR sky130_fd_sc_hd__decap_3
XTAP_TAPCELL_ROW_13_123 VGND VPWR sky130_fd_sc_hd__tapvpwrvgnd_1
XFILLER_8_81 VGND VGND VPWR VPWR sky130_fd_sc_hd__decap_3
XFILLER_27_57 VGND VGND VPWR VPWR sky130_fd_sc_hd__decap_3
XFILLER_27_35 VGND VGND VPWR VPWR sky130_fd_sc_hd__decap_3
XFILLER_4_113 VGND VGND VPWR VPWR sky130_fd_sc_hd__decap_3
X_587_ _597_/C _597_/D VGND VGND VPWR VPWR _587_/Y sky130_fd_sc_hd__nand2_2
X_656_ _656_/A _656_/B VGND VGND VPWR VPWR _657_/B sky130_fd_sc_hd__nand2_2
X_725_ _725_/A _725_/B VGND VGND VPWR VPWR _725_/Y sky130_fd_sc_hd__nor2_4
XFILLER_31_201 VGND VGND VPWR VPWR sky130_fd_sc_hd__fill_1
XFILLER_1_149 VGND VGND VPWR VPWR sky130_fd_sc_hd__fill_2
X_510_ _474_/X _484_/X _492_/X _506_/B VGND VGND VPWR VPWR _510_/X sky130_fd_sc_hd__o31a_2
X_441_ _659_/A _659_/B _442_/B _443_/A VGND VGND VPWR VPWR _447_/B sky130_fd_sc_hd__and4_2
X_372_ _652_/A _370_/B input30/X VGND VGND VPWR VPWR _372_/Y sky130_fd_sc_hd__a21boi_2
XFILLER_0_160 VGND VGND VPWR VPWR sky130_fd_sc_hd__decap_3
X_639_ _722_/X _639_/B VGND VGND VPWR VPWR _639_/X sky130_fd_sc_hd__xor2_2
X_708_ _709_/A _709_/B _709_/C _709_/D VGND VGND VPWR VPWR _708_/X sky130_fd_sc_hd__and4_2
XFILLER_5_71 VGND VGND VPWR VPWR sky130_fd_sc_hd__decap_3
XFILLER_24_58 VGND VGND VPWR VPWR sky130_fd_sc_hd__fill_1
X_424_ _692_/X _685_/Y _415_/Y _422_/Y VGND VGND VPWR VPWR _425_/B sky130_fd_sc_hd__o22ai_4
XPHY_EDGE_ROW_23_Left_59 VGND VGND VPWR VPWR sky130_fd_sc_hd__decap_3
XFILLER_14_91 VGND VGND VPWR VPWR sky130_fd_sc_hd__decap_3
X_355_ _351_/B _353_/B _653_/A VGND VGND VPWR VPWR _355_/Y sky130_fd_sc_hd__a21boi_2
Xinput6 A[14] VGND VGND VPWR VPWR input6/X sky130_fd_sc_hd__clkdlybuf4s25_1
XFILLER_19_47 VGND VGND VPWR VPWR sky130_fd_sc_hd__decap_3
XFILLER_35_57 VGND VGND VPWR VPWR sky130_fd_sc_hd__fill_1
XFILLER_35_35 VGND VGND VPWR VPWR sky130_fd_sc_hd__decap_3
XFILLER_35_24 VGND VGND VPWR VPWR sky130_fd_sc_hd__decap_3
XFILLER_27_178 VGND VGND VPWR VPWR sky130_fd_sc_hd__fill_1
XFILLER_27_123 VGND VGND VPWR VPWR sky130_fd_sc_hd__decap_3
XPHY_EDGE_ROW_14_Right_14 VGND VGND VPWR VPWR sky130_fd_sc_hd__decap_3
XPHY_EDGE_ROW_23_Right_23 VGND VGND VPWR VPWR sky130_fd_sc_hd__decap_3
XFILLER_18_112 VGND VGND VPWR VPWR sky130_fd_sc_hd__decap_3
X_407_ _728_/X _730_/Y _356_/Y VGND VGND VPWR VPWR _407_/Y sky130_fd_sc_hd__o21ai_2
XTAP_TAPCELL_ROW_28_173 VGND VPWR sky130_fd_sc_hd__tapvpwrvgnd_1
XPHY_EDGE_ROW_32_Right_32 VGND VGND VPWR VPWR sky130_fd_sc_hd__decap_3
XFILLER_2_72 VGND VGND VPWR VPWR sky130_fd_sc_hd__decap_3
XFILLER_24_159 VGND VGND VPWR VPWR sky130_fd_sc_hd__decap_3
XFILLER_32_192 VGND VGND VPWR VPWR sky130_fd_sc_hd__decap_3
XFILLER_15_137 VGND VGND VPWR VPWR sky130_fd_sc_hd__decap_3
XTAP_TAPCELL_ROW_25_165 VGND VPWR sky130_fd_sc_hd__tapvpwrvgnd_1
XFILLER_23_181 VGND VGND VPWR VPWR sky130_fd_sc_hd__decap_3
XFILLER_7_28 VGND VGND VPWR VPWR sky130_fd_sc_hd__decap_3
XFILLER_11_81 VGND VGND VPWR VPWR sky130_fd_sc_hd__decap_3
XTAP_TAPCELL_ROW_16_132 VGND VPWR sky130_fd_sc_hd__tapvpwrvgnd_1
Xinput20 A[27] VGND VGND VPWR VPWR input20/X sky130_fd_sc_hd__clkdlybuf4s25_1
Xinput31 A[8] VGND VGND VPWR VPWR _704_/B1 sky130_fd_sc_hd__clkdlybuf4s25_1
XPHY_EDGE_ROW_26_Left_62 VGND VGND VPWR VPWR sky130_fd_sc_hd__decap_3
XFILLER_21_129 VGND VGND VPWR VPWR sky130_fd_sc_hd__fill_2
Xinput42 B[18] VGND VGND VPWR VPWR _436_/B sky130_fd_sc_hd__clkdlybuf4s25_1
Xinput64 B[9] VGND VGND VPWR VPWR _695_/B sky130_fd_sc_hd__clkdlybuf4s25_1
Xinput53 B[28] VGND VGND VPWR VPWR _566_/B sky130_fd_sc_hd__clkdlybuf4s25_1
XPHY_EDGE_ROW_10_Left_46 VGND VGND VPWR VPWR sky130_fd_sc_hd__decap_3
XFILLER_32_58 VGND VGND VPWR VPWR sky130_fd_sc_hd__decap_3
XFILLER_32_25 VGND VGND VPWR VPWR sky130_fd_sc_hd__decap_3
XFILLER_20_195 VGND VGND VPWR VPWR sky130_fd_sc_hd__fill_1
XTAP_TAPCELL_ROW_7_100 VGND VPWR sky130_fd_sc_hd__tapvpwrvgnd_1
X_672_ _717_/A _673_/B VGND VGND VPWR VPWR _674_/A sky130_fd_sc_hd__nor2_2
XFILLER_7_100 VGND VGND VPWR VPWR sky130_fd_sc_hd__decap_3
XFILLER_11_184 VGND VGND VPWR VPWR sky130_fd_sc_hd__decap_3
XFILLER_11_195 VGND VGND VPWR VPWR sky130_fd_sc_hd__decap_3
XFILLER_7_166 VGND VGND VPWR VPWR sky130_fd_sc_hd__fill_2
XFILLER_22_91 VGND VGND VPWR VPWR sky130_fd_sc_hd__decap_3
XPHY_EDGE_ROW_4_Right_4 VGND VGND VPWR VPWR sky130_fd_sc_hd__decap_3
XFILLER_27_69 VGND VGND VPWR VPWR sky130_fd_sc_hd__decap_3
XFILLER_27_47 VGND VGND VPWR VPWR sky130_fd_sc_hd__decap_3
XFILLER_25_210 VGND VGND VPWR VPWR sky130_fd_sc_hd__fill_1
XFILLER_4_29 VGND VGND VPWR VPWR sky130_fd_sc_hd__fill_1
XFILLER_4_147 VGND VGND VPWR VPWR sky130_fd_sc_hd__decap_3
X_724_ _718_/Y _717_/X _716_/B _716_/A _721_/Y VGND VGND VPWR VPWR _725_/A sky130_fd_sc_hd__o2111ai_2
X_586_ _584_/A _584_/B input22/X VGND VGND VPWR VPWR _597_/D sky130_fd_sc_hd__o21bai_2
X_655_ _656_/A _656_/B VGND VGND VPWR VPWR _655_/X sky130_fd_sc_hd__and2_4
XFILLER_1_139 VGND VGND VPWR VPWR sky130_fd_sc_hd__fill_2
XFILLER_1_117 VGND VGND VPWR VPWR sky130_fd_sc_hd__decap_3
X_440_ _440_/A _440_/B VGND VGND VPWR VPWR _464_/C sky130_fd_sc_hd__nand2_2
X_371_ _370_/X _369_/Y input30/X VGND VGND VPWR VPWR _411_/C sky130_fd_sc_hd__o21bai_4
XFILLER_0_194 VGND VGND VPWR VPWR sky130_fd_sc_hd__fill_2
X_707_ _709_/C _709_/D VGND VGND VPWR VPWR _707_/Y sky130_fd_sc_hd__nand2_2
X_569_ _569_/A _569_/B input21/X VGND VGND VPWR VPWR _597_/B sky130_fd_sc_hd__or3b_2
X_638_ _716_/Y _637_/B _716_/B VGND VGND VPWR VPWR _639_/B sky130_fd_sc_hd__o21ai_2
XFILLER_5_83 VGND VGND VPWR VPWR sky130_fd_sc_hd__decap_3
XFILLER_24_37 VGND VGND VPWR VPWR sky130_fd_sc_hd__fill_2
X_423_ _423_/A _640_/B _640_/A _423_/D VGND VGND VPWR VPWR _447_/D sky130_fd_sc_hd__nand4_2
X_354_ _728_/A _353_/B _653_/A VGND VGND VPWR VPWR _354_/X sky130_fd_sc_hd__o21a_2
XFILLER_30_91 VGND VGND VPWR VPWR sky130_fd_sc_hd__decap_3
XFILLER_30_80 VGND VGND VPWR VPWR sky130_fd_sc_hd__decap_3
Xinput7 A[15] VGND VGND VPWR VPWR input7/X sky130_fd_sc_hd__clkdlybuf4s25_1
XFILLER_27_135 VGND VGND VPWR VPWR sky130_fd_sc_hd__decap_3
XFILLER_27_102 VGND VGND VPWR VPWR sky130_fd_sc_hd__decap_3
XTAP_TAPCELL_ROW_28_174 VGND VPWR sky130_fd_sc_hd__tapvpwrvgnd_1
XFILLER_18_124 VGND VGND VPWR VPWR sky130_fd_sc_hd__decap_3
X_406_ _627_/A _406_/B _729_/Y _406_/D VGND VGND VPWR VPWR _409_/B sky130_fd_sc_hd__nand4_2
XFILLER_25_80 VGND VGND VPWR VPWR sky130_fd_sc_hd__fill_1
XFILLER_21_27 VGND VGND VPWR VPWR sky130_fd_sc_hd__decap_3
XFILLER_15_116 VGND VGND VPWR VPWR sky130_fd_sc_hd__decap_3
XFILLER_15_149 VGND VGND VPWR VPWR sky130_fd_sc_hd__decap_3
XFILLER_30_119 VGND VGND VPWR VPWR sky130_fd_sc_hd__decap_3
XFILLER_11_60 VGND VGND VPWR VPWR sky130_fd_sc_hd__decap_3
XFILLER_11_93 VGND VGND VPWR VPWR sky130_fd_sc_hd__fill_2
XTAP_TAPCELL_ROW_16_133 VGND VPWR sky130_fd_sc_hd__tapvpwrvgnd_1
Xinput10 A[18] VGND VGND VPWR VPWR _438_/C sky130_fd_sc_hd__clkdlybuf4s25_1
Xinput21 A[28] VGND VGND VPWR VPWR input21/X sky130_fd_sc_hd__clkdlybuf4s25_1
Xinput32 A[9] VGND VGND VPWR VPWR input32/X sky130_fd_sc_hd__clkdlybuf4s25_1
Xinput43 B[19] VGND VGND VPWR VPWR _449_/B sky130_fd_sc_hd__clkdlybuf4s25_1
Xinput54 B[29] VGND VGND VPWR VPWR _583_/B sky130_fd_sc_hd__clkdlybuf4s25_1
Xinput65 sub VGND VGND VPWR VPWR input65/X sky130_fd_sc_hd__buf_8
XFILLER_16_27 VGND VGND VPWR VPWR sky130_fd_sc_hd__fill_1
XTAP_TAPCELL_ROW_30_180 VGND VPWR sky130_fd_sc_hd__tapvpwrvgnd_1
XFILLER_32_48 VGND VGND VPWR VPWR sky130_fd_sc_hd__fill_2
XTAP_TAPCELL_ROW_7_101 VGND VPWR sky130_fd_sc_hd__tapvpwrvgnd_1
X_671_ _667_/Y _671_/B _671_/C VGND VGND VPWR VPWR _691_/B sky130_fd_sc_hd__nand3b_2
XFILLER_11_141 VGND VGND VPWR VPWR sky130_fd_sc_hd__decap_3
XFILLER_22_81 VGND VGND VPWR VPWR sky130_fd_sc_hd__decap_3
XFILLER_34_200 VGND VGND VPWR VPWR sky130_fd_sc_hd__decap_3
XFILLER_21_6 VGND VGND VPWR VPWR sky130_fd_sc_hd__decap_3
XFILLER_8_61 VGND VGND VPWR VPWR sky130_fd_sc_hd__decap_3
XFILLER_27_26 VGND VGND VPWR VPWR sky130_fd_sc_hd__decap_3
XFILLER_4_137 VGND VGND VPWR VPWR sky130_fd_sc_hd__decap_3
X_654_ _656_/A _656_/B VGND VGND VPWR VPWR _654_/Y sky130_fd_sc_hd__nor2_8
X_723_ _718_/Y _717_/X _716_/B _716_/A _721_/Y VGND VGND VPWR VPWR _723_/X sky130_fd_sc_hd__o2111a_2
X_585_ _584_/A _584_/B input22/X VGND VGND VPWR VPWR _585_/X sky130_fd_sc_hd__o21ba_2
XFILLER_17_70 VGND VGND VPWR VPWR sky130_fd_sc_hd__decap_3
X_370_ _652_/A _370_/B VGND VGND VPWR VPWR _370_/X sky130_fd_sc_hd__and2_4
X_637_ _716_/Y _637_/B VGND VGND VPWR VPWR _637_/X sky130_fd_sc_hd__xor2_2
X_706_ _704_/B1 _706_/B _706_/C VGND VGND VPWR VPWR _709_/D sky130_fd_sc_hd__nand3b_2
XFILLER_28_91 VGND VGND VPWR VPWR sky130_fd_sc_hd__decap_3
X_499_ _499_/A _499_/B VGND VGND VPWR VPWR _499_/X sky130_fd_sc_hd__and2_4
X_568_ _569_/A _569_/B input21/X VGND VGND VPWR VPWR _568_/Y sky130_fd_sc_hd__nor3b_2
XFILLER_5_95 VGND VGND VPWR VPWR sky130_fd_sc_hd__decap_3
XFILLER_24_27 VGND VGND VPWR VPWR sky130_fd_sc_hd__fill_1
XFILLER_24_16 VGND VGND VPWR VPWR sky130_fd_sc_hd__fill_2
XFILLER_14_60 VGND VGND VPWR VPWR sky130_fd_sc_hd__decap_3
X_422_ _640_/C _684_/Y VGND VGND VPWR VPWR _422_/Y sky130_fd_sc_hd__nand2_4
X_353_ _353_/A _353_/B VGND VGND VPWR VPWR _353_/Y sky130_fd_sc_hd__nand2_2
XFILLER_14_82 VGND VGND VPWR VPWR sky130_fd_sc_hd__fill_2
XFILLER_5_210 VGND VGND VPWR VPWR sky130_fd_sc_hd__fill_1
Xinput8 A[16] VGND VGND VPWR VPWR _657_/C sky130_fd_sc_hd__clkdlybuf4s25_1
XFILLER_10_29 VGND VGND VPWR VPWR sky130_fd_sc_hd__fill_2
XFILLER_35_15 VGND VGND VPWR VPWR sky130_fd_sc_hd__decap_3
XFILLER_27_169 VGND VGND VPWR VPWR sky130_fd_sc_hd__decap_3
XFILLER_2_202 VGND VGND VPWR VPWR sky130_fd_sc_hd__decap_3
XTAP_TAPCELL_ROW_28_175 VGND VPWR sky130_fd_sc_hd__tapvpwrvgnd_1
X_405_ _397_/Y _395_/X _402_/X _418_/A _418_/B VGND VGND VPWR VPWR _410_/A sky130_fd_sc_hd__o2111a_2
XTAP_TAPCELL_ROW_19_142 VGND VPWR sky130_fd_sc_hd__tapvpwrvgnd_1
XFILLER_24_117 VGND VGND VPWR VPWR sky130_fd_sc_hd__fill_2
XFILLER_15_106 VGND VGND VPWR VPWR sky130_fd_sc_hd__decap_3
XFILLER_15_128 VGND VGND VPWR VPWR sky130_fd_sc_hd__decap_3
XFILLER_23_172 VGND VGND VPWR VPWR sky130_fd_sc_hd__decap_3
XFILLER_23_150 VGND VGND VPWR VPWR sky130_fd_sc_hd__decap_3
XFILLER_11_72 VGND VGND VPWR VPWR sky130_fd_sc_hd__decap_3
XFILLER_14_150 VGND VGND VPWR VPWR sky130_fd_sc_hd__decap_3
XTAP_TAPCELL_ROW_16_134 VGND VPWR sky130_fd_sc_hd__tapvpwrvgnd_1
XFILLER_21_109 VGND VGND VPWR VPWR sky130_fd_sc_hd__decap_3
Xinput11 A[19] VGND VGND VPWR VPWR _452_/A sky130_fd_sc_hd__clkdlybuf4s25_1
Xinput22 A[29] VGND VGND VPWR VPWR input22/X sky130_fd_sc_hd__clkdlybuf4s25_1
Xinput33 B[0] VGND VGND VPWR VPWR _616_/S sky130_fd_sc_hd__dlygate4sd1_1
Xinput44 B[1] VGND VGND VPWR VPWR _382_/B sky130_fd_sc_hd__clkdlybuf4s25_1
Xinput55 B[2] VGND VGND VPWR VPWR _395_/B sky130_fd_sc_hd__clkdlybuf4s25_1
XFILLER_12_109 VGND VGND VPWR VPWR sky130_fd_sc_hd__decap_3
XFILLER_32_16 VGND VGND VPWR VPWR sky130_fd_sc_hd__decap_3
XTAP_TAPCELL_ROW_7_102 VGND VPWR sky130_fd_sc_hd__tapvpwrvgnd_1
XTAP_TAPCELL_ROW_30_181 VGND VPWR sky130_fd_sc_hd__tapvpwrvgnd_1
XFILLER_20_197 VGND VGND VPWR VPWR sky130_fd_sc_hd__decap_3
XFILLER_20_186 VGND VGND VPWR VPWR sky130_fd_sc_hd__decap_3
X_670_ _667_/Y _668_/X _671_/C VGND VGND VPWR VPWR _691_/C sky130_fd_sc_hd__o21bai_2
XFILLER_11_153 VGND VGND VPWR VPWR sky130_fd_sc_hd__fill_1
XFILLER_11_164 VGND VGND VPWR VPWR sky130_fd_sc_hd__decap_3
XFILLER_27_38 VGND VGND VPWR VPWR sky130_fd_sc_hd__decap_3
XFILLER_4_116 VGND VGND VPWR VPWR sky130_fd_sc_hd__decap_3
X_653_ _653_/A VGND VGND VPWR VPWR _653_/Y sky130_fd_sc_hd__inv_2
X_722_ _717_/X _718_/Y _721_/Y VGND VGND VPWR VPWR _722_/X sky130_fd_sc_hd__o21a_2
X_584_ _584_/A _584_/B input22/X VGND VGND VPWR VPWR _597_/C sky130_fd_sc_hd__or3b_2
XFILLER_17_82 VGND VGND VPWR VPWR sky130_fd_sc_hd__decap_3
XFILLER_17_60 VGND VGND VPWR VPWR sky130_fd_sc_hd__decap_3
X_567_ _569_/A _569_/B input21/X VGND VGND VPWR VPWR _597_/A sky130_fd_sc_hd__o21bai_2
X_636_ _633_/B _708_/X _412_/Y VGND VGND VPWR VPWR _637_/B sky130_fd_sc_hd__a21oi_2
X_705_ _705_/A _705_/B VGND VGND VPWR VPWR _709_/C sky130_fd_sc_hd__nand2_4
XFILLER_28_81 VGND VGND VPWR VPWR sky130_fd_sc_hd__decap_3
X_498_ _498_/A _499_/B VGND VGND VPWR VPWR _498_/Y sky130_fd_sc_hd__nor2_2
XFILLER_5_74 VGND VGND VPWR VPWR sky130_fd_sc_hd__decap_3
X_421_ _725_/Y _420_/B _420_/A _685_/Y VGND VGND VPWR VPWR _423_/A sky130_fd_sc_hd__a31oi_2
XFILLER_14_94 VGND VGND VPWR VPWR sky130_fd_sc_hd__decap_3
X_352_ _351_/B _353_/B VGND VGND VPWR VPWR _358_/C sky130_fd_sc_hd__nand2b_4
Xinput9 A[17] VGND VGND VPWR VPWR _429_/C sky130_fd_sc_hd__clkdlybuf4s25_1
X_619_ _385_/Y _390_/Y _416_/Y _410_/C VGND VGND VPWR VPWR _622_/C sky130_fd_sc_hd__a211o_4
XFILLER_35_38 VGND VGND VPWR VPWR sky130_fd_sc_hd__fill_2
XFILLER_35_27 VGND VGND VPWR VPWR sky130_fd_sc_hd__fill_1
XFILLER_27_126 VGND VGND VPWR VPWR sky130_fd_sc_hd__decap_3
XFILLER_18_115 VGND VGND VPWR VPWR sky130_fd_sc_hd__decap_3
X_404_ _399_/X _401_/Y _418_/B VGND VGND VPWR VPWR _622_/B sky130_fd_sc_hd__o21ai_2
XTAP_TAPCELL_ROW_28_176 VGND VPWR sky130_fd_sc_hd__tapvpwrvgnd_1
XFILLER_25_60 VGND VGND VPWR VPWR sky130_fd_sc_hd__decap_3
XFILLER_18_137 VGND VGND VPWR VPWR sky130_fd_sc_hd__decap_3
XTAP_TAPCELL_ROW_19_143 VGND VPWR sky130_fd_sc_hd__tapvpwrvgnd_1
XPHY_EDGE_ROW_10_Right_10 VGND VGND VPWR VPWR sky130_fd_sc_hd__decap_3
XFILLER_2_75 VGND VGND VPWR VPWR sky130_fd_sc_hd__fill_1
XFILLER_32_195 VGND VGND VPWR VPWR sky130_fd_sc_hd__fill_1
XFILLER_23_184 VGND VGND VPWR VPWR sky130_fd_sc_hd__decap_3
XFILLER_23_162 VGND VGND VPWR VPWR sky130_fd_sc_hd__decap_3
XFILLER_11_51 VGND VGND VPWR VPWR sky130_fd_sc_hd__decap_3
XFILLER_11_84 VGND VGND VPWR VPWR sky130_fd_sc_hd__decap_3
Xinput12 A[1] VGND VGND VPWR VPWR _383_/B sky130_fd_sc_hd__clkdlybuf4s25_1
Xinput23 A[2] VGND VGND VPWR VPWR _397_/B1 sky130_fd_sc_hd__clkdlybuf4s25_1
Xinput34 B[10] VGND VGND VPWR VPWR _712_/B sky130_fd_sc_hd__clkdlybuf4s25_1
Xinput45 B[20] VGND VGND VPWR VPWR _459_/B sky130_fd_sc_hd__clkdlybuf4s25_1
Xinput56 B[30] VGND VGND VPWR VPWR _592_/B sky130_fd_sc_hd__clkdlybuf4s25_1
XFILLER_16_29 VGND VGND VPWR VPWR sky130_fd_sc_hd__decap_3
XTAP_TAPCELL_ROW_30_182 VGND VPWR sky130_fd_sc_hd__tapvpwrvgnd_1
XFILLER_11_132 VGND VGND VPWR VPWR sky130_fd_sc_hd__decap_3
XFILLER_11_198 VGND VGND VPWR VPWR sky130_fd_sc_hd__decap_3
XFILLER_7_169 VGND VGND VPWR VPWR sky130_fd_sc_hd__fill_2
XFILLER_7_136 VGND VGND VPWR VPWR sky130_fd_sc_hd__decap_3
XFILLER_7_103 VGND VGND VPWR VPWR sky130_fd_sc_hd__decap_3
XFILLER_22_94 VGND VGND VPWR VPWR sky130_fd_sc_hd__decap_3
XFILLER_22_72 VGND VGND VPWR VPWR sky130_fd_sc_hd__decap_3
XFILLER_8_85 VGND VGND VPWR VPWR sky130_fd_sc_hd__decap_3
X_583_ _606_/A _583_/B VGND VGND VPWR VPWR _584_/B sky130_fd_sc_hd__and2_2
X_652_ _652_/A VGND VGND VPWR VPWR _727_/A sky130_fd_sc_hd__inv_8
X_721_ _727_/A _717_/B _720_/Y VGND VGND VPWR VPWR _721_/Y sky130_fd_sc_hd__o21ai_4
XFILLER_3_150 VGND VGND VPWR VPWR sky130_fd_sc_hd__fill_1
XPHY_EDGE_ROW_8_Right_8 VGND VGND VPWR VPWR sky130_fd_sc_hd__decap_3
XFILLER_0_175 VGND VGND VPWR VPWR sky130_fd_sc_hd__decap_3
XFILLER_0_197 VGND VGND VPWR VPWR sky130_fd_sc_hd__decap_3
X_704_ _726_/B _702_/B _704_/B1 VGND VGND VPWR VPWR _705_/A sky130_fd_sc_hd__o21a_4
X_566_ _566_/A _566_/B VGND VGND VPWR VPWR _569_/B sky130_fd_sc_hd__and2_2
X_635_ _700_/Y _635_/B VGND VGND VPWR VPWR _635_/Y sky130_fd_sc_hd__xnor2_2
X_497_ _497_/A _497_/B VGND VGND VPWR VPWR _497_/Y sky130_fd_sc_hd__nand2_4
XFILLER_5_86 VGND VGND VPWR VPWR sky130_fd_sc_hd__decap_3
XPHY_EDGE_ROW_17_Left_53 VGND VGND VPWR VPWR sky130_fd_sc_hd__decap_3
X_420_ _420_/A _420_/B _725_/Y VGND VGND VPWR VPWR _640_/C sky130_fd_sc_hd__nand3_2
X_351_ _353_/B _351_/B VGND VGND VPWR VPWR _358_/B sky130_fd_sc_hd__nand2b_4
XFILLER_14_51 VGND VGND VPWR VPWR sky130_fd_sc_hd__decap_3
XFILLER_30_94 VGND VGND VPWR VPWR sky130_fd_sc_hd__decap_3
XFILLER_30_83 VGND VGND VPWR VPWR sky130_fd_sc_hd__fill_1
X_549_ _549_/A _549_/B VGND VGND VPWR VPWR _571_/B sky130_fd_sc_hd__and2_2
X_618_ _390_/Y _385_/Y _384_/Y _410_/C VGND VGND VPWR VPWR _620_/B sky130_fd_sc_hd__a211o_2
XFILLER_27_138 VGND VGND VPWR VPWR sky130_fd_sc_hd__decap_3
XFILLER_27_105 VGND VGND VPWR VPWR sky130_fd_sc_hd__decap_3
XPHY_EDGE_ROW_2_Left_38 VGND VGND VPWR VPWR sky130_fd_sc_hd__decap_3
XFILLER_18_127 VGND VGND VPWR VPWR sky130_fd_sc_hd__fill_1
X_403_ _400_/Y _399_/X _401_/B1 VGND VGND VPWR VPWR _418_/B sky130_fd_sc_hd__o21bai_4
XTAP_TAPCELL_ROW_19_144 VGND VPWR sky130_fd_sc_hd__tapvpwrvgnd_1
XFILLER_24_108 VGND VGND VPWR VPWR sky130_fd_sc_hd__decap_3
XFILLER_15_119 VGND VGND VPWR VPWR sky130_fd_sc_hd__decap_3
XFILLER_23_141 VGND VGND VPWR VPWR sky130_fd_sc_hd__decap_3
XTAP_TAPCELL_ROW_33_191 VGND VPWR sky130_fd_sc_hd__tapvpwrvgnd_1
XFILLER_11_63 VGND VGND VPWR VPWR sky130_fd_sc_hd__decap_3
XFILLER_2_3 VGND VGND VPWR VPWR sky130_fd_sc_hd__decap_3
XFILLER_14_130 VGND VGND VPWR VPWR sky130_fd_sc_hd__decap_3
XFILLER_14_141 VGND VGND VPWR VPWR sky130_fd_sc_hd__decap_3
Xinput13 A[20] VGND VGND VPWR VPWR _460_/B1 sky130_fd_sc_hd__clkdlybuf4s25_1
Xinput24 A[30] VGND VGND VPWR VPWR input24/X sky130_fd_sc_hd__clkdlybuf4s25_1
Xinput35 B[11] VGND VGND VPWR VPWR _717_/B sky130_fd_sc_hd__clkdlybuf4s25_1
Xinput46 B[21] VGND VGND VPWR VPWR _473_/B sky130_fd_sc_hd__clkdlybuf4s25_1
Xinput57 B[31] VGND VGND VPWR VPWR _606_/B sky130_fd_sc_hd__clkdlybuf4s25_1
XFILLER_35_3 VGND VGND VPWR VPWR sky130_fd_sc_hd__decap_3
XTAP_TAPCELL_ROW_30_183 VGND VPWR sky130_fd_sc_hd__tapvpwrvgnd_1
XFILLER_32_29 VGND VGND VPWR VPWR sky130_fd_sc_hd__decap_3
XFILLER_20_177 VGND VGND VPWR VPWR sky130_fd_sc_hd__decap_3
XFILLER_20_122 VGND VGND VPWR VPWR sky130_fd_sc_hd__fill_2
XFILLER_11_111 VGND VGND VPWR VPWR sky130_fd_sc_hd__fill_1
XFILLER_11_144 VGND VGND VPWR VPWR sky130_fd_sc_hd__decap_3
XTAP_TAPCELL_ROW_21_150 VGND VPWR sky130_fd_sc_hd__tapvpwrvgnd_1
XPHY_EDGE_ROW_5_Left_41 VGND VGND VPWR VPWR sky130_fd_sc_hd__decap_3
XFILLER_21_9 VGND VGND VPWR VPWR sky130_fd_sc_hd__fill_1
XFILLER_34_203 VGND VGND VPWR VPWR sky130_fd_sc_hd__decap_3
XFILLER_8_64 VGND VGND VPWR VPWR sky130_fd_sc_hd__fill_1
XFILLER_6_170 VGND VGND VPWR VPWR sky130_fd_sc_hd__fill_2
XFILLER_27_29 VGND VGND VPWR VPWR sky130_fd_sc_hd__decap_3
X_720_ _727_/A _717_/B input3/X VGND VGND VPWR VPWR _720_/Y sky130_fd_sc_hd__a21oi_4
XPHY_EDGE_ROW_31_Left_67 VGND VGND VPWR VPWR sky130_fd_sc_hd__decap_3
X_582_ _606_/A _583_/B VGND VGND VPWR VPWR _584_/A sky130_fd_sc_hd__nor2_2
X_651_ _607_/A _607_/B _613_/X _610_/Y VGND VGND VPWR VPWR _651_/Y sky130_fd_sc_hd__o2bb2ai_4
XFILLER_17_73 VGND VGND VPWR VPWR sky130_fd_sc_hd__decap_3
XFILLER_3_195 VGND VGND VPWR VPWR sky130_fd_sc_hd__decap_3
X_634_ _705_/A _705_/B _633_/B _709_/D VGND VGND VPWR VPWR _635_/B sky130_fd_sc_hd__a22o_2
X_703_ _702_/B _726_/B VGND VGND VPWR VPWR _706_/C sky130_fd_sc_hd__nand2b_4
X_565_ _565_/A _566_/B VGND VGND VPWR VPWR _569_/A sky130_fd_sc_hd__nor2_2
X_496_ _496_/A _496_/B VGND VGND VPWR VPWR _497_/B sky130_fd_sc_hd__nand2_2
XFILLER_28_94 VGND VGND VPWR VPWR sky130_fd_sc_hd__decap_3
XFILLER_5_98 VGND VGND VPWR VPWR sky130_fd_sc_hd__decap_3
XFILLER_10_209 VGND VGND VPWR VPWR sky130_fd_sc_hd__fill_2
X_350_ _728_/X _730_/Y _729_/Y VGND VGND VPWR VPWR _629_/A sky130_fd_sc_hd__o21ai_2
XFILLER_14_63 VGND VGND VPWR VPWR sky130_fd_sc_hd__fill_1
XFILLER_14_85 VGND VGND VPWR VPWR sky130_fd_sc_hd__decap_3
X_617_ _617_/A _617_/B VGND VGND VPWR VPWR _617_/Y sky130_fd_sc_hd__xnor2_2
XPHY_EDGE_ROW_34_Left_70 VGND VGND VPWR VPWR sky130_fd_sc_hd__decap_3
X_548_ _547_/A _547_/B input19/X VGND VGND VPWR VPWR _549_/B sky130_fd_sc_hd__o21bai_2
X_479_ _471_/A _471_/B _458_/X _460_/Y VGND VGND VPWR VPWR _479_/Y sky130_fd_sc_hd__o2bb2ai_2
XFILLER_35_29 VGND VGND VPWR VPWR sky130_fd_sc_hd__decap_3
XFILLER_35_194 VGND VGND VPWR VPWR sky130_fd_sc_hd__fill_2
XFILLER_35_18 VGND VGND VPWR VPWR sky130_fd_sc_hd__decap_3
XFILLER_2_205 VGND VGND VPWR VPWR sky130_fd_sc_hd__decap_3
X_402_ _426_/A _400_/B _401_/Y VGND VGND VPWR VPWR _402_/X sky130_fd_sc_hd__a21o_2
XFILLER_25_73 VGND VGND VPWR VPWR sky130_fd_sc_hd__fill_2
XFILLER_2_44 VGND VGND VPWR VPWR sky130_fd_sc_hd__decap_3
XFILLER_17_172 VGND VGND VPWR VPWR sky130_fd_sc_hd__decap_3
XFILLER_32_197 VGND VGND VPWR VPWR sky130_fd_sc_hd__decap_3
XFILLER_32_164 VGND VGND VPWR VPWR sky130_fd_sc_hd__decap_3
XFILLER_15_109 VGND VGND VPWR VPWR sky130_fd_sc_hd__decap_3
XFILLER_23_175 VGND VGND VPWR VPWR sky130_fd_sc_hd__decap_3
XFILLER_23_153 VGND VGND VPWR VPWR sky130_fd_sc_hd__decap_3
XFILLER_11_75 VGND VGND VPWR VPWR sky130_fd_sc_hd__decap_3
XTAP_TAPCELL_ROW_33_192 VGND VPWR sky130_fd_sc_hd__tapvpwrvgnd_1
XFILLER_14_153 VGND VGND VPWR VPWR sky130_fd_sc_hd__decap_3
XFILLER_14_197 VGND VGND VPWR VPWR sky130_fd_sc_hd__fill_1
Xinput14 A[21] VGND VGND VPWR VPWR _476_/B1 sky130_fd_sc_hd__clkdlybuf4s25_1
Xinput25 A[31] VGND VGND VPWR VPWR _607_/A sky130_fd_sc_hd__clkdlybuf4s25_1
Xinput36 B[12] VGND VGND VPWR VPWR _673_/B sky130_fd_sc_hd__clkdlybuf4s25_1
Xinput47 B[22] VGND VGND VPWR VPWR _490_/B sky130_fd_sc_hd__clkdlybuf4s25_1
Xinput58 B[3] VGND VGND VPWR VPWR _400_/B sky130_fd_sc_hd__clkdlybuf4s25_1
XFILLER_32_19 VGND VGND VPWR VPWR sky130_fd_sc_hd__decap_3
XFILLER_20_189 VGND VGND VPWR VPWR sky130_fd_sc_hd__decap_3
XFILLER_11_167 VGND VGND VPWR VPWR sky130_fd_sc_hd__fill_1
XFILLER_11_178 VGND VGND VPWR VPWR sky130_fd_sc_hd__decap_3
XTAP_TAPCELL_ROW_21_151 VGND VPWR sky130_fd_sc_hd__tapvpwrvgnd_1
XFILLER_22_85 VGND VGND VPWR VPWR sky130_fd_sc_hd__decap_3
XFILLER_22_63 VGND VGND VPWR VPWR sky130_fd_sc_hd__decap_3
XFILLER_6_182 VGND VGND VPWR VPWR sky130_fd_sc_hd__decap_3
XFILLER_25_204 VGND VGND VPWR VPWR sky130_fd_sc_hd__decap_3
X_650_ _650_/A _650_/B VGND VGND VPWR VPWR _650_/Y sky130_fd_sc_hd__nor2_4
X_581_ _579_/Y _581_/B VGND VGND VPWR VPWR _581_/X sky130_fd_sc_hd__and2b_4
XFILLER_17_85 VGND VGND VPWR VPWR sky130_fd_sc_hd__decap_3
Xmax_cap100 _517_/Y VGND VGND VPWR VPWR _575_/A1 sky130_fd_sc_hd__buf_6
X_633_ _707_/Y _633_/B VGND VGND VPWR VPWR _633_/Y sky130_fd_sc_hd__xnor2_2
X_702_ _727_/A _702_/B VGND VGND VPWR VPWR _706_/B sky130_fd_sc_hd__nand2_2
X_564_ _559_/Y _563_/Y _562_/Y VGND VGND VPWR VPWR _564_/Y sky130_fd_sc_hd__o21ai_2
X_495_ _507_/A _506_/A _486_/Y _496_/B VGND VGND VPWR VPWR _497_/A sky130_fd_sc_hd__a211o_4
XFILLER_5_44 VGND VGND VPWR VPWR sky130_fd_sc_hd__decap_3
XFILLER_5_22 VGND VGND VPWR VPWR sky130_fd_sc_hd__decap_3
XFILLER_5_77 VGND VGND VPWR VPWR sky130_fd_sc_hd__decap_3
XFILLER_14_97 VGND VGND VPWR VPWR sky130_fd_sc_hd__decap_3
XFILLER_30_52 VGND VGND VPWR VPWR sky130_fd_sc_hd__decap_3
XFILLER_30_41 VGND VGND VPWR VPWR sky130_fd_sc_hd__fill_1
XFILLER_30_85 VGND VGND VPWR VPWR sky130_fd_sc_hd__decap_3
X_547_ _547_/A _547_/B input19/X VGND VGND VPWR VPWR _549_/A sky130_fd_sc_hd__or3b_4
X_616_ _351_/B _615_/A _616_/S VGND VGND VPWR VPWR _617_/B sky130_fd_sc_hd__mux2_2
X_478_ _473_/X _476_/Y _475_/Y VGND VGND VPWR VPWR _515_/C sky130_fd_sc_hd__o21ai_2
XFILLER_27_129 VGND VGND VPWR VPWR sky130_fd_sc_hd__decap_3
X_401_ _426_/A _400_/B _401_/B1 VGND VGND VPWR VPWR _401_/Y sky130_fd_sc_hd__o21ai_4
XFILLER_18_118 VGND VGND VPWR VPWR sky130_fd_sc_hd__decap_3
XFILLER_25_63 VGND VGND VPWR VPWR sky130_fd_sc_hd__decap_3
XFILLER_17_140 VGND VGND VPWR VPWR sky130_fd_sc_hd__decap_3
XTAP_TAPCELL_ROW_33_193 VGND VPWR sky130_fd_sc_hd__tapvpwrvgnd_1
XFILLER_23_187 VGND VGND VPWR VPWR sky130_fd_sc_hd__fill_1
XFILLER_23_165 VGND VGND VPWR VPWR sky130_fd_sc_hd__decap_3
XFILLER_23_132 VGND VGND VPWR VPWR sky130_fd_sc_hd__decap_3
XFILLER_11_54 VGND VGND VPWR VPWR sky130_fd_sc_hd__fill_2
XFILLER_11_87 VGND VGND VPWR VPWR sky130_fd_sc_hd__decap_3
XFILLER_14_121 VGND VGND VPWR VPWR sky130_fd_sc_hd__decap_3
Xinput15 A[22] VGND VGND VPWR VPWR _491_/C sky130_fd_sc_hd__clkdlybuf4s25_1
Xinput26 A[3] VGND VGND VPWR VPWR _401_/B1 sky130_fd_sc_hd__clkdlybuf4s25_1
Xinput37 B[13] VGND VGND VPWR VPWR _669_/B sky130_fd_sc_hd__clkdlybuf4s25_1
Xinput48 B[23] VGND VGND VPWR VPWR _499_/B sky130_fd_sc_hd__clkdlybuf4s25_1
Xinput59 B[4] VGND VGND VPWR VPWR _362_/B sky130_fd_sc_hd__clkdlybuf4s25_1
XTAP_TAPCELL_ROW_24_160 VGND VPWR sky130_fd_sc_hd__tapvpwrvgnd_1
XFILLER_11_102 VGND VGND VPWR VPWR sky130_fd_sc_hd__decap_3
XFILLER_11_113 VGND VGND VPWR VPWR sky130_fd_sc_hd__decap_3
XFILLER_11_135 VGND VGND VPWR VPWR sky130_fd_sc_hd__decap_3
XFILLER_7_139 VGND VGND VPWR VPWR sky130_fd_sc_hd__fill_2
XFILLER_7_106 VGND VGND VPWR VPWR sky130_fd_sc_hd__decap_3
XFILLER_22_75 VGND VGND VPWR VPWR sky130_fd_sc_hd__decap_3
XFILLER_22_97 VGND VGND VPWR VPWR sky130_fd_sc_hd__decap_3
XFILLER_8_88 VGND VGND VPWR VPWR sky130_fd_sc_hd__fill_1
XFILLER_8_55 VGND VGND VPWR VPWR sky130_fd_sc_hd__decap_3
XTAP_TAPCELL_ROW_35_200 VGND VPWR sky130_fd_sc_hd__tapvpwrvgnd_1
X_580_ _597_/A _597_/B _605_/A VGND VGND VPWR VPWR _581_/B sky130_fd_sc_hd__a21o_2
XTAP_TAPCELL_ROW_4_89 VGND VPWR sky130_fd_sc_hd__tapvpwrvgnd_1
XFILLER_33_74 VGND VGND VPWR VPWR sky130_fd_sc_hd__fill_2
XPHY_EDGE_ROW_17_Right_17 VGND VGND VPWR VPWR sky130_fd_sc_hd__decap_3
XFILLER_0_123 VGND VGND VPWR VPWR sky130_fd_sc_hd__decap_3
XFILLER_0_167 VGND VGND VPWR VPWR sky130_fd_sc_hd__fill_1
XFILLER_0_178 VGND VGND VPWR VPWR sky130_fd_sc_hd__decap_3
XPHY_EDGE_ROW_26_Right_26 VGND VGND VPWR VPWR sky130_fd_sc_hd__decap_3
X_563_ _563_/A _571_/C VGND VGND VPWR VPWR _563_/Y sky130_fd_sc_hd__nand2_2
X_632_ _411_/C _411_/A _378_/X _625_/B VGND VGND VPWR VPWR _633_/B sky130_fd_sc_hd__o2bb2ai_2
X_701_ _726_/B _702_/B VGND VGND VPWR VPWR _705_/B sky130_fd_sc_hd__nand2_2
XFILLER_28_85 VGND VGND VPWR VPWR sky130_fd_sc_hd__decap_3
XFILLER_28_52 VGND VGND VPWR VPWR sky130_fd_sc_hd__decap_3
X_494_ _506_/B _506_/C VGND VGND VPWR VPWR _496_/B sky130_fd_sc_hd__nand2_2
XPHY_EDGE_ROW_35_Right_35 VGND VGND VPWR VPWR sky130_fd_sc_hd__decap_3
XFILLER_5_89 VGND VGND VPWR VPWR sky130_fd_sc_hd__decap_3
XFILLER_14_54 VGND VGND VPWR VPWR sky130_fd_sc_hd__decap_3
XFILLER_30_97 VGND VGND VPWR VPWR sky130_fd_sc_hd__decap_3
XTAP_TAPCELL_ROW_1_79 VGND VPWR sky130_fd_sc_hd__tapvpwrvgnd_1
X_546_ _546_/A _546_/B VGND VGND VPWR VPWR _547_/B sky130_fd_sc_hd__and2_2
X_615_ _615_/A _616_/S VGND VGND VPWR VPWR _615_/X sky130_fd_sc_hd__xor2_2
XFILLER_29_160 VGND VGND VPWR VPWR sky130_fd_sc_hd__decap_3
X_477_ _473_/A _473_/B _476_/Y VGND VGND VPWR VPWR _477_/Y sky130_fd_sc_hd__a21oi_2
XFILLER_27_108 VGND VGND VPWR VPWR sky130_fd_sc_hd__decap_3
X_400_ _426_/A _400_/B VGND VGND VPWR VPWR _400_/Y sky130_fd_sc_hd__nor2_2
XFILLER_26_174 VGND VGND VPWR VPWR sky130_fd_sc_hd__fill_2
XFILLER_26_130 VGND VGND VPWR VPWR sky130_fd_sc_hd__fill_1
XFILLER_25_53 VGND VGND VPWR VPWR sky130_fd_sc_hd__decap_3
XFILLER_25_97 VGND VGND VPWR VPWR sky130_fd_sc_hd__decap_3
X_529_ _529_/A1 _520_/Y _558_/A VGND VGND VPWR VPWR _538_/B sky130_fd_sc_hd__a21o_2
XFILLER_17_152 VGND VGND VPWR VPWR sky130_fd_sc_hd__decap_3
XFILLER_23_111 VGND VGND VPWR VPWR sky130_fd_sc_hd__fill_1
XFILLER_23_144 VGND VGND VPWR VPWR sky130_fd_sc_hd__decap_3
XFILLER_11_66 VGND VGND VPWR VPWR sky130_fd_sc_hd__decap_3
XFILLER_2_6 VGND VGND VPWR VPWR sky130_fd_sc_hd__decap_3
XFILLER_14_100 VGND VGND VPWR VPWR sky130_fd_sc_hd__decap_3
XFILLER_14_133 VGND VGND VPWR VPWR sky130_fd_sc_hd__decap_3
XFILLER_14_144 VGND VGND VPWR VPWR sky130_fd_sc_hd__decap_3
XFILLER_14_166 VGND VGND VPWR VPWR sky130_fd_sc_hd__decap_3
XFILLER_14_177 VGND VGND VPWR VPWR sky130_fd_sc_hd__fill_1
XTAP_TAPCELL_ROW_24_161 VGND VPWR sky130_fd_sc_hd__tapvpwrvgnd_1
Xinput16 A[23] VGND VGND VPWR VPWR _502_/B1 sky130_fd_sc_hd__clkdlybuf4s25_1
Xinput27 A[4] VGND VGND VPWR VPWR _364_/B1 sky130_fd_sc_hd__clkdlybuf4s25_1
Xinput38 B[14] VGND VGND VPWR VPWR _664_/B sky130_fd_sc_hd__clkdlybuf4s25_1
Xinput49 B[24] VGND VGND VPWR VPWR _523_/B sky130_fd_sc_hd__clkdlybuf4s25_1
XFILLER_35_6 VGND VGND VPWR VPWR sky130_fd_sc_hd__decap_3
XFILLER_20_169 VGND VGND VPWR VPWR sky130_fd_sc_hd__fill_1
XFILLER_20_147 VGND VGND VPWR VPWR sky130_fd_sc_hd__decap_3
XFILLER_11_147 VGND VGND VPWR VPWR sky130_fd_sc_hd__decap_3
XFILLER_0_3 VGND VGND VPWR VPWR sky130_fd_sc_hd__decap_3
XFILLER_34_206 VGND VGND VPWR VPWR sky130_fd_sc_hd__decap_3
XTAP_TAPCELL_ROW_12_120 VGND VPWR sky130_fd_sc_hd__tapvpwrvgnd_1
XTAP_TAPCELL_ROW_35_201 VGND VPWR sky130_fd_sc_hd__tapvpwrvgnd_1
XPHY_EDGE_ROW_9_Left_45 VGND VGND VPWR VPWR sky130_fd_sc_hd__decap_3
XFILLER_17_76 VGND VGND VPWR VPWR sky130_fd_sc_hd__fill_1
XFILLER_3_121 VGND VGND VPWR VPWR sky130_fd_sc_hd__decap_3
XFILLER_3_198 VGND VGND VPWR VPWR sky130_fd_sc_hd__decap_3
XFILLER_13_209 VGND VGND VPWR VPWR sky130_fd_sc_hd__fill_2
XFILLER_0_113 VGND VGND VPWR VPWR sky130_fd_sc_hd__fill_2
XFILLER_0_157 VGND VGND VPWR VPWR sky130_fd_sc_hd__decap_3
X_700_ _709_/A _709_/B VGND VGND VPWR VPWR _700_/Y sky130_fd_sc_hd__nand2_2
X_562_ _559_/Y _561_/Y _571_/C VGND VGND VPWR VPWR _562_/Y sky130_fd_sc_hd__o21bai_2
X_631_ _631_/A _631_/B VGND VGND VPWR VPWR _631_/X sky130_fd_sc_hd__xor2_2
X_493_ _489_/X _488_/Y _491_/C VGND VGND VPWR VPWR _493_/Y sky130_fd_sc_hd__o21bai_4
XFILLER_28_97 VGND VGND VPWR VPWR sky130_fd_sc_hd__decap_3
XFILLER_28_42 VGND VGND VPWR VPWR sky130_fd_sc_hd__decap_3
XFILLER_8_202 VGND VGND VPWR VPWR sky130_fd_sc_hd__fill_1
XFILLER_5_68 VGND VGND VPWR VPWR sky130_fd_sc_hd__decap_3
XFILLER_14_88 VGND VGND VPWR VPWR sky130_fd_sc_hd__decap_3
XFILLER_29_172 VGND VGND VPWR VPWR sky130_fd_sc_hd__fill_2
X_545_ _546_/A _546_/B VGND VGND VPWR VPWR _547_/A sky130_fd_sc_hd__nor2_2
X_614_ _609_/X _605_/Y _611_/Y _612_/Y VGND VGND VPWR VPWR _614_/Y sky130_fd_sc_hd__a22oi_4
X_476_ _473_/A _473_/B _476_/B1 VGND VGND VPWR VPWR _476_/Y sky130_fd_sc_hd__o21ai_2
XFILLER_29_183 VGND VGND VPWR VPWR sky130_fd_sc_hd__decap_3
XFILLER_35_197 VGND VGND VPWR VPWR sky130_fd_sc_hd__decap_3
XFILLER_2_208 VGND VGND VPWR VPWR sky130_fd_sc_hd__decap_3
Xrebuffer140 fanout105/X VGND VGND VPWR VPWR _428_/A sky130_fd_sc_hd__buf_2
XPHY_EDGE_ROW_22_Left_58 VGND VGND VPWR VPWR sky130_fd_sc_hd__decap_3
XFILLER_2_47 VGND VGND VPWR VPWR sky130_fd_sc_hd__fill_1
X_528_ _520_/Y _529_/A1 _558_/A VGND VGND VPWR VPWR _528_/Y sky130_fd_sc_hd__a21oi_2
X_459_ _606_/A _459_/B VGND VGND VPWR VPWR _459_/Y sky130_fd_sc_hd__nor2_2
XTAP_TAPCELL_ROW_27_170 VGND VPWR sky130_fd_sc_hd__tapvpwrvgnd_1
XFILLER_32_189 VGND VGND VPWR VPWR sky130_fd_sc_hd__decap_3
XFILLER_17_175 VGND VGND VPWR VPWR sky130_fd_sc_hd__decap_3
XFILLER_23_156 VGND VGND VPWR VPWR sky130_fd_sc_hd__decap_3
XFILLER_23_178 VGND VGND VPWR VPWR sky130_fd_sc_hd__decap_3
XFILLER_11_78 VGND VGND VPWR VPWR sky130_fd_sc_hd__decap_3
XFILLER_14_112 VGND VGND VPWR VPWR sky130_fd_sc_hd__decap_3
XFILLER_14_156 VGND VGND VPWR VPWR sky130_fd_sc_hd__decap_3
XTAP_TAPCELL_ROW_24_162 VGND VPWR sky130_fd_sc_hd__tapvpwrvgnd_1
Xinput17 A[24] VGND VGND VPWR VPWR _525_/C sky130_fd_sc_hd__clkdlybuf4s25_1
Xinput28 A[5] VGND VGND VPWR VPWR _653_/A sky130_fd_sc_hd__clkdlybuf4s25_1
Xinput39 B[15] VGND VGND VPWR VPWR _661_/B sky130_fd_sc_hd__clkdlybuf4s25_1
XFILLER_9_193 VGND VGND VPWR VPWR sky130_fd_sc_hd__decap_3
XFILLER_9_182 VGND VGND VPWR VPWR sky130_fd_sc_hd__fill_2
XFILLER_9_160 VGND VGND VPWR VPWR sky130_fd_sc_hd__decap_3
XFILLER_22_88 VGND VGND VPWR VPWR sky130_fd_sc_hd__decap_3
XFILLER_22_66 VGND VGND VPWR VPWR sky130_fd_sc_hd__decap_3
XFILLER_22_44 VGND VGND VPWR VPWR sky130_fd_sc_hd__decap_3
XFILLER_6_185 VGND VGND VPWR VPWR sky130_fd_sc_hd__decap_3
XFILLER_6_141 VGND VGND VPWR VPWR sky130_fd_sc_hd__fill_1
XPHY_EDGE_ROW_25_Left_61 VGND VGND VPWR VPWR sky130_fd_sc_hd__decap_3
XFILLER_26_3 VGND VGND VPWR VPWR sky130_fd_sc_hd__decap_3
XTAP_TAPCELL_ROW_35_202 VGND VPWR sky130_fd_sc_hd__tapvpwrvgnd_1
XFILLER_25_207 VGND VGND VPWR VPWR sky130_fd_sc_hd__decap_3
XFILLER_33_21 VGND VGND VPWR VPWR sky130_fd_sc_hd__decap_3
XPHY_EDGE_ROW_3_Right_3 VGND VGND VPWR VPWR sky130_fd_sc_hd__decap_3
XFILLER_0_169 VGND VGND VPWR VPWR sky130_fd_sc_hd__fill_2
X_630_ _729_/Y _407_/Y _378_/A _627_/B VGND VGND VPWR VPWR _631_/B sky130_fd_sc_hd__o2bb2a_2
XFILLER_12_210 VGND VGND VPWR VPWR sky130_fd_sc_hd__fill_1
X_561_ _563_/A VGND VGND VPWR VPWR _561_/Y sky130_fd_sc_hd__inv_2
X_492_ _488_/Y _489_/X _491_/C VGND VGND VPWR VPWR _492_/X sky130_fd_sc_hd__o21ba_2
XFILLER_5_25 VGND VGND VPWR VPWR sky130_fd_sc_hd__fill_1
XFILLER_30_88 VGND VGND VPWR VPWR sky130_fd_sc_hd__decap_3
XFILLER_30_55 VGND VGND VPWR VPWR sky130_fd_sc_hd__decap_3
X_613_ _613_/A _613_/B VGND VGND VPWR VPWR _613_/X sky130_fd_sc_hd__or2_2
XFILLER_29_195 VGND VGND VPWR VPWR sky130_fd_sc_hd__fill_2
XFILLER_29_151 VGND VGND VPWR VPWR sky130_fd_sc_hd__decap_3
X_544_ _544_/A VGND VGND VPWR VPWR _551_/B sky130_fd_sc_hd__inv_2
X_475_ _472_/Y _473_/X _476_/B1 VGND VGND VPWR VPWR _475_/Y sky130_fd_sc_hd__o21bai_4
XFILLER_35_165 VGND VGND VPWR VPWR sky130_fd_sc_hd__decap_3
XFILLER_26_121 VGND VGND VPWR VPWR sky130_fd_sc_hd__decap_3
XFILLER_25_66 VGND VGND VPWR VPWR sky130_fd_sc_hd__fill_2
Xrebuffer141 _566_/A VGND VGND VPWR VPWR _565_/A sky130_fd_sc_hd__buf_2
Xrebuffer130 _640_/D VGND VGND VPWR VPWR _423_/D sky130_fd_sc_hd__buf_2
X_527_ _538_/C _527_/B VGND VGND VPWR VPWR _558_/A sky130_fd_sc_hd__nand2_2
XFILLER_17_143 VGND VGND VPWR VPWR sky130_fd_sc_hd__decap_3
XFILLER_17_110 VGND VGND VPWR VPWR sky130_fd_sc_hd__fill_2
X_458_ _592_/A _459_/B VGND VGND VPWR VPWR _458_/X sky130_fd_sc_hd__and2_4
X_389_ _388_/A _616_/S _615_/A VGND VGND VPWR VPWR _389_/Y sky130_fd_sc_hd__o21ai_2
XTAP_TAPCELL_ROW_27_171 VGND VPWR sky130_fd_sc_hd__tapvpwrvgnd_1
XFILLER_23_135 VGND VGND VPWR VPWR sky130_fd_sc_hd__decap_3
XFILLER_23_113 VGND VGND VPWR VPWR sky130_fd_sc_hd__decap_3
XFILLER_11_57 VGND VGND VPWR VPWR sky130_fd_sc_hd__decap_3
XFILLER_14_124 VGND VGND VPWR VPWR sky130_fd_sc_hd__decap_3
Xinput18 A[25] VGND VGND VPWR VPWR _535_/B1 sky130_fd_sc_hd__clkdlybuf4s25_1
Xinput29 A[6] VGND VGND VPWR VPWR _730_/B1 sky130_fd_sc_hd__clkdlybuf4s25_1
XTAP_TAPCELL_ROW_15_130 VGND VPWR sky130_fd_sc_hd__tapvpwrvgnd_1
XFILLER_11_105 VGND VGND VPWR VPWR sky130_fd_sc_hd__decap_3
XFILLER_11_116 VGND VGND VPWR VPWR sky130_fd_sc_hd__fill_2
XFILLER_11_138 VGND VGND VPWR VPWR sky130_fd_sc_hd__decap_3
XFILLER_7_109 VGND VGND VPWR VPWR sky130_fd_sc_hd__decap_3
XFILLER_22_78 VGND VGND VPWR VPWR sky130_fd_sc_hd__decap_3
XFILLER_8_58 VGND VGND VPWR VPWR sky130_fd_sc_hd__decap_3
XFILLER_8_25 VGND VGND VPWR VPWR sky130_fd_sc_hd__decap_3
XFILLER_6_164 VGND VGND VPWR VPWR sky130_fd_sc_hd__decap_3
XTAP_TAPCELL_ROW_35_203 VGND VPWR sky130_fd_sc_hd__tapvpwrvgnd_1
XFILLER_17_67 VGND VGND VPWR VPWR sky130_fd_sc_hd__decap_3
XFILLER_33_55 VGND VGND VPWR VPWR sky130_fd_sc_hd__fill_1
XFILLER_3_178 VGND VGND VPWR VPWR sky130_fd_sc_hd__fill_2
XFILLER_0_126 VGND VGND VPWR VPWR sky130_fd_sc_hd__fill_2
X_560_ _544_/A _549_/B _549_/A VGND VGND VPWR VPWR _563_/A sky130_fd_sc_hd__a21boi_2
XFILLER_28_88 VGND VGND VPWR VPWR sky130_fd_sc_hd__decap_3
XFILLER_28_55 VGND VGND VPWR VPWR sky130_fd_sc_hd__fill_2
X_491_ _488_/Y _491_/B _491_/C VGND VGND VPWR VPWR _491_/Y sky130_fd_sc_hd__nand3b_4
X_689_ _691_/C _691_/B VGND VGND VPWR VPWR _689_/Y sky130_fd_sc_hd__nand2_2
XPHY_EDGE_ROW_13_Right_13 VGND VGND VPWR VPWR sky130_fd_sc_hd__decap_3
XPHY_EDGE_ROW_22_Right_22 VGND VGND VPWR VPWR sky130_fd_sc_hd__decap_3
XPHY_EDGE_ROW_31_Right_31 VGND VGND VPWR VPWR sky130_fd_sc_hd__decap_3
XFILLER_14_57 VGND VGND VPWR VPWR sky130_fd_sc_hd__decap_3
XFILLER_14_79 VGND VGND VPWR VPWR sky130_fd_sc_hd__decap_3
X_543_ _538_/C _536_/X _534_/X VGND VGND VPWR VPWR _544_/A sky130_fd_sc_hd__a21oi_2
X_612_ _613_/A _613_/B VGND VGND VPWR VPWR _612_/Y sky130_fd_sc_hd__nor2_2
XFILLER_29_163 VGND VGND VPWR VPWR sky130_fd_sc_hd__decap_3
X_474_ _472_/Y _473_/X _476_/B1 VGND VGND VPWR VPWR _474_/X sky130_fd_sc_hd__o21ba_2
XFILLER_26_155 VGND VGND VPWR VPWR sky130_fd_sc_hd__decap_3
XFILLER_26_100 VGND VGND VPWR VPWR sky130_fd_sc_hd__decap_3
XFILLER_25_12 VGND VGND VPWR VPWR sky130_fd_sc_hd__fill_1
Xrebuffer142 _573_/Y VGND VGND VPWR VPWR _578_/A3 sky130_fd_sc_hd__buf_2
Xrebuffer131 _415_/Y VGND VGND VPWR VPWR _520_/B2 sky130_fd_sc_hd__buf_4
XFILLER_2_27 VGND VGND VPWR VPWR sky130_fd_sc_hd__fill_1
X_526_ _521_/Y _522_/X _525_/C VGND VGND VPWR VPWR _527_/B sky130_fd_sc_hd__o21bai_2
XTAP_TAPCELL_ROW_27_172 VGND VPWR sky130_fd_sc_hd__tapvpwrvgnd_1
XFILLER_32_114 VGND VGND VPWR VPWR sky130_fd_sc_hd__decap_3
XFILLER_17_155 VGND VGND VPWR VPWR sky130_fd_sc_hd__decap_3
X_457_ _457_/A _457_/B VGND VGND VPWR VPWR _457_/Y sky130_fd_sc_hd__nand2_2
X_388_ _388_/A _616_/S VGND VGND VPWR VPWR _388_/Y sky130_fd_sc_hd__nor2_2
XFILLER_23_169 VGND VGND VPWR VPWR sky130_fd_sc_hd__decap_3
XFILLER_23_147 VGND VGND VPWR VPWR sky130_fd_sc_hd__decap_3
XFILLER_11_69 VGND VGND VPWR VPWR sky130_fd_sc_hd__decap_3
XFILLER_31_180 VGND VGND VPWR VPWR sky130_fd_sc_hd__decap_3
XFILLER_2_9 VGND VGND VPWR VPWR sky130_fd_sc_hd__fill_2
XFILLER_14_103 VGND VGND VPWR VPWR sky130_fd_sc_hd__decap_3
XFILLER_14_136 VGND VGND VPWR VPWR sky130_fd_sc_hd__decap_3
XFILLER_14_147 VGND VGND VPWR VPWR sky130_fd_sc_hd__decap_3
Xinput19 A[26] VGND VGND VPWR VPWR input19/X sky130_fd_sc_hd__clkdlybuf4s25_1
XFILLER_35_9 VGND VGND VPWR VPWR sky130_fd_sc_hd__decap_3
X_509_ _492_/X _486_/A _506_/B VGND VGND VPWR VPWR _509_/Y sky130_fd_sc_hd__o21ai_2
XFILLER_9_151 VGND VGND VPWR VPWR sky130_fd_sc_hd__decap_3
XFILLER_28_206 VGND VGND VPWR VPWR sky130_fd_sc_hd__decap_3
XFILLER_0_6 VGND VGND VPWR VPWR sky130_fd_sc_hd__decap_3
XFILLER_34_209 VGND VGND VPWR VPWR sky130_fd_sc_hd__fill_2
XFILLER_10_150 VGND VGND VPWR VPWR sky130_fd_sc_hd__decap_3
XFILLER_10_172 VGND VGND VPWR VPWR sky130_fd_sc_hd__decap_3
XFILLER_6_132 VGND VGND VPWR VPWR sky130_fd_sc_hd__decap_3
XTAP_TAPCELL_ROW_35_204 VGND VPWR sky130_fd_sc_hd__tapvpwrvgnd_1
XFILLER_17_57 VGND VGND VPWR VPWR sky130_fd_sc_hd__decap_3
XFILLER_33_45 VGND VGND VPWR VPWR sky130_fd_sc_hd__fill_2
XFILLER_31_3 VGND VGND VPWR VPWR sky130_fd_sc_hd__decap_3
XFILLER_0_60 VGND VGND VPWR VPWR sky130_fd_sc_hd__decap_3
XFILLER_28_78 VGND VGND VPWR VPWR sky130_fd_sc_hd__decap_3
XFILLER_28_45 VGND VGND VPWR VPWR sky130_fd_sc_hd__fill_2
X_490_ _499_/A _490_/B VGND VGND VPWR VPWR _491_/B sky130_fd_sc_hd__nand2_2
X_688_ _665_/A _666_/Y _680_/Y VGND VGND VPWR VPWR _688_/X sky130_fd_sc_hd__o21a_2
XFILLER_30_35 VGND VGND VPWR VPWR sky130_fd_sc_hd__decap_3
X_542_ _559_/A2 _520_/Y _571_/A VGND VGND VPWR VPWR _542_/Y sky130_fd_sc_hd__a21boi_2
X_611_ _611_/A _611_/B VGND VGND VPWR VPWR _611_/Y sky130_fd_sc_hd__nand2_2
X_473_ _473_/A _473_/B VGND VGND VPWR VPWR _473_/X sky130_fd_sc_hd__and2_4
XFILLER_26_112 VGND VGND VPWR VPWR sky130_fd_sc_hd__decap_3
Xrebuffer132 _573_/B VGND VGND VPWR VPWR _530_/A2 sky130_fd_sc_hd__buf_2
XFILLER_25_57 VGND VGND VPWR VPWR sky130_fd_sc_hd__decap_3
Xrebuffer154 _499_/A VGND VGND VPWR VPWR _498_/A sky130_fd_sc_hd__buf_2
XFILLER_17_101 VGND VGND VPWR VPWR sky130_fd_sc_hd__decap_3
X_525_ _521_/Y _525_/B _525_/C VGND VGND VPWR VPWR _538_/C sky130_fd_sc_hd__nand3b_2
X_456_ _456_/A _466_/B _456_/C _466_/A VGND VGND VPWR VPWR _457_/B sky130_fd_sc_hd__nand4_2
XFILLER_17_178 VGND VGND VPWR VPWR sky130_fd_sc_hd__fill_2
XFILLER_17_134 VGND VGND VPWR VPWR sky130_fd_sc_hd__decap_3
X_387_ _388_/A _616_/S VGND VGND VPWR VPWR _387_/X sky130_fd_sc_hd__and2_4
XTAP_TAPCELL_ROW_2_82 VGND VPWR sky130_fd_sc_hd__tapvpwrvgnd_1
XTAP_TAPCELL_ROW_18_140 VGND VPWR sky130_fd_sc_hd__tapvpwrvgnd_1
XFILLER_31_192 VGND VGND VPWR VPWR sky130_fd_sc_hd__decap_3
XFILLER_23_159 VGND VGND VPWR VPWR sky130_fd_sc_hd__decap_3
XFILLER_23_126 VGND VGND VPWR VPWR sky130_fd_sc_hd__decap_3
XFILLER_11_37 VGND VGND VPWR VPWR sky130_fd_sc_hd__fill_2
XFILLER_14_115 VGND VGND VPWR VPWR sky130_fd_sc_hd__decap_3
XFILLER_22_170 VGND VGND VPWR VPWR sky130_fd_sc_hd__decap_3
X_508_ _515_/A _477_/Y _506_/C _475_/Y VGND VGND VPWR VPWR _508_/Y sky130_fd_sc_hd__o211ai_2
X_439_ _437_/A _437_/B _438_/C VGND VGND VPWR VPWR _440_/B sky130_fd_sc_hd__o21bai_4
XFILLER_9_196 VGND VGND VPWR VPWR sky130_fd_sc_hd__fill_1
XFILLER_9_163 VGND VGND VPWR VPWR sky130_fd_sc_hd__decap_3
XFILLER_22_69 VGND VGND VPWR VPWR sky130_fd_sc_hd__decap_3
XFILLER_12_91 VGND VGND VPWR VPWR sky130_fd_sc_hd__decap_3
XFILLER_6_188 VGND VGND VPWR VPWR sky130_fd_sc_hd__fill_1
XFILLER_6_155 VGND VGND VPWR VPWR sky130_fd_sc_hd__fill_2
XFILLER_33_57 VGND VGND VPWR VPWR sky130_fd_sc_hd__fill_2
XFILLER_33_24 VGND VGND VPWR VPWR sky130_fd_sc_hd__decap_3
XFILLER_3_169 VGND VGND VPWR VPWR sky130_fd_sc_hd__fill_2
XFILLER_3_147 VGND VGND VPWR VPWR sky130_fd_sc_hd__decap_3
XPHY_EDGE_ROW_29_Left_65 VGND VGND VPWR VPWR sky130_fd_sc_hd__decap_3
XFILLER_23_90 VGND VGND VPWR VPWR sky130_fd_sc_hd__decap_3
XPHY_EDGE_ROW_13_Left_49 VGND VGND VPWR VPWR sky130_fd_sc_hd__decap_3
XFILLER_0_94 VGND VGND VPWR VPWR sky130_fd_sc_hd__fill_2
XFILLER_0_139 VGND VGND VPWR VPWR sky130_fd_sc_hd__fill_1
XFILLER_28_24 VGND VGND VPWR VPWR sky130_fd_sc_hd__decap_3
X_687_ _674_/B _675_/Y _686_/Y VGND VGND VPWR VPWR _692_/D sky130_fd_sc_hd__o21a_2
XTAP_TAPCELL_ROW_5_93 VGND VPWR sky130_fd_sc_hd__tapvpwrvgnd_1
Xload_slew120 fanout119/X VGND VGND VPWR VPWR _499_/A sky130_fd_sc_hd__buf_8
XPHY_EDGE_ROW_7_Right_7 VGND VGND VPWR VPWR sky130_fd_sc_hd__decap_3
XFILLER_14_26 VGND VGND VPWR VPWR sky130_fd_sc_hd__fill_2
XFILLER_30_58 VGND VGND VPWR VPWR sky130_fd_sc_hd__fill_1
XFILLER_30_25 VGND VGND VPWR VPWR sky130_fd_sc_hd__decap_3
X_610_ _605_/A _605_/D _611_/B VGND VGND VPWR VPWR _610_/Y sky130_fd_sc_hd__a21boi_2
XFILLER_29_154 VGND VGND VPWR VPWR sky130_fd_sc_hd__decap_3
X_541_ _558_/A _558_/B VGND VGND VPWR VPWR _571_/A sky130_fd_sc_hd__nor2_2
X_472_ _473_/A _473_/B VGND VGND VPWR VPWR _472_/Y sky130_fd_sc_hd__nor2_2
XFILLER_35_113 VGND VGND VPWR VPWR sky130_fd_sc_hd__decap_3
XFILLER_6_82 VGND VGND VPWR VPWR sky130_fd_sc_hd__fill_2
XPHY_EDGE_ROW_16_Left_52 VGND VGND VPWR VPWR sky130_fd_sc_hd__decap_3
XFILLER_26_124 VGND VGND VPWR VPWR sky130_fd_sc_hd__decap_3
Xrebuffer155 fanout119/X VGND VGND VPWR VPWR _523_/A sky130_fd_sc_hd__buf_2
Xrebuffer133 _692_/X VGND VGND VPWR VPWR _520_/A1 sky130_fd_sc_hd__buf_4
Xrebuffer122 _425_/B VGND VGND VPWR VPWR _530_/A1 sky130_fd_sc_hd__buf_2
XFILLER_2_29 VGND VGND VPWR VPWR sky130_fd_sc_hd__fill_1
XFILLER_17_146 VGND VGND VPWR VPWR sky130_fd_sc_hd__decap_3
XFILLER_17_113 VGND VGND VPWR VPWR sky130_fd_sc_hd__decap_3
XFILLER_15_91 VGND VGND VPWR VPWR sky130_fd_sc_hd__fill_1
X_524_ _521_/Y _525_/B _525_/C VGND VGND VPWR VPWR _524_/X sky130_fd_sc_hd__and3b_2
X_455_ _466_/B _456_/C _456_/A _466_/A VGND VGND VPWR VPWR _457_/A sky130_fd_sc_hd__a22o_2
X_386_ _384_/B _384_/A _385_/Y VGND VGND VPWR VPWR _393_/B sky130_fd_sc_hd__o21ai_4
Xoutput90 _614_/Y VGND VGND VPWR VPWR S[31] sky130_fd_sc_hd__buf_6
XTAP_TAPCELL_ROW_2_83 VGND VPWR sky130_fd_sc_hd__tapvpwrvgnd_1
XTAP_TAPCELL_ROW_18_141 VGND VPWR sky130_fd_sc_hd__tapvpwrvgnd_1
XFILLER_23_138 VGND VGND VPWR VPWR sky130_fd_sc_hd__decap_3
XFILLER_23_116 VGND VGND VPWR VPWR sky130_fd_sc_hd__decap_3
XPHY_EDGE_ROW_1_Left_37 VGND VGND VPWR VPWR sky130_fd_sc_hd__decap_3
XFILLER_14_127 VGND VGND VPWR VPWR sky130_fd_sc_hd__decap_3
XFILLER_22_193 VGND VGND VPWR VPWR sky130_fd_sc_hd__decap_3
XFILLER_22_182 VGND VGND VPWR VPWR sky130_fd_sc_hd__fill_2
XFILLER_13_182 VGND VGND VPWR VPWR sky130_fd_sc_hd__decap_3
X_507_ _507_/A _507_/B VGND VGND VPWR VPWR _507_/Y sky130_fd_sc_hd__nand2_2
X_438_ _437_/A _438_/B _438_/C VGND VGND VPWR VPWR _440_/A sky130_fd_sc_hd__nand3b_2
X_369_ _726_/B _370_/B VGND VGND VPWR VPWR _369_/Y sky130_fd_sc_hd__nor2_2
XFILLER_9_142 VGND VGND VPWR VPWR sky130_fd_sc_hd__decap_3
XFILLER_20_119 VGND VGND VPWR VPWR sky130_fd_sc_hd__decap_3
XFILLER_11_108 VGND VGND VPWR VPWR sky130_fd_sc_hd__decap_3
XFILLER_22_37 VGND VGND VPWR VPWR sky130_fd_sc_hd__fill_2
Xfanout121 input65/X VGND VGND VPWR VPWR fanout121/X sky130_fd_sc_hd__buf_8
XFILLER_10_141 VGND VGND VPWR VPWR sky130_fd_sc_hd__decap_3
XFILLER_12_70 VGND VGND VPWR VPWR sky130_fd_sc_hd__decap_3
XFILLER_6_167 VGND VGND VPWR VPWR sky130_fd_sc_hd__decap_3
XFILLER_24_200 VGND VGND VPWR VPWR sky130_fd_sc_hd__decap_3
XFILLER_15_200 VGND VGND VPWR VPWR sky130_fd_sc_hd__fill_2
XPHY_EDGE_ROW_4_Left_40 VGND VGND VPWR VPWR sky130_fd_sc_hd__decap_3
XFILLER_9_60 VGND VGND VPWR VPWR sky130_fd_sc_hd__decap_3
XFILLER_9_82 VGND VGND VPWR VPWR sky130_fd_sc_hd__decap_3
XFILLER_28_36 VGND VGND VPWR VPWR sky130_fd_sc_hd__decap_3
XPHY_EDGE_ROW_30_Left_66 VGND VGND VPWR VPWR sky130_fd_sc_hd__decap_3
XFILLER_18_80 VGND VGND VPWR VPWR sky130_fd_sc_hd__decap_3
X_686_ _674_/A _674_/B _677_/C VGND VGND VPWR VPWR _686_/Y sky130_fd_sc_hd__o21bai_2
XTAP_TAPCELL_ROW_5_94 VGND VPWR sky130_fd_sc_hd__tapvpwrvgnd_1
Xload_slew110 _606_/A VGND VGND VPWR VPWR _592_/A sky130_fd_sc_hd__buf_2
X_540_ _540_/A _540_/B VGND VGND VPWR VPWR _540_/Y sky130_fd_sc_hd__nand2_2
XFILLER_29_166 VGND VGND VPWR VPWR sky130_fd_sc_hd__fill_2
X_471_ _471_/A _471_/B VGND VGND VPWR VPWR _471_/X sky130_fd_sc_hd__xor2_4
XFILLER_20_81 VGND VGND VPWR VPWR sky130_fd_sc_hd__decap_3
X_669_ _669_/A _669_/B VGND VGND VPWR VPWR _671_/B sky130_fd_sc_hd__nand2_2
XFILLER_35_147 VGND VGND VPWR VPWR sky130_fd_sc_hd__fill_2
XFILLER_29_90 VGND VGND VPWR VPWR sky130_fd_sc_hd__fill_1
XFILLER_26_103 VGND VGND VPWR VPWR sky130_fd_sc_hd__decap_3
XFILLER_26_158 VGND VGND VPWR VPWR sky130_fd_sc_hd__fill_2
Xrebuffer156 _514_/A1 VGND VGND VPWR VPWR rebuffer156/X sky130_fd_sc_hd__buf_2
Xrebuffer134 _692_/X VGND VGND VPWR VPWR _574_/A2 sky130_fd_sc_hd__buf_4
Xrebuffer123 _415_/Y VGND VGND VPWR VPWR _574_/B2 sky130_fd_sc_hd__buf_4
XFILLER_1_202 VGND VGND VPWR VPWR sky130_fd_sc_hd__decap_3
X_523_ _523_/A _523_/B VGND VGND VPWR VPWR _525_/B sky130_fd_sc_hd__nand2_2
XFILLER_17_169 VGND VGND VPWR VPWR sky130_fd_sc_hd__decap_3
X_454_ _466_/B _456_/C VGND VGND VPWR VPWR _464_/D sky130_fd_sc_hd__nand2_2
X_385_ _383_/B _385_/B _385_/C VGND VGND VPWR VPWR _385_/Y sky130_fd_sc_hd__nand3b_4
XFILLER_32_117 VGND VGND VPWR VPWR sky130_fd_sc_hd__decap_3
XTAP_TAPCELL_ROW_2_84 VGND VPWR sky130_fd_sc_hd__tapvpwrvgnd_1
Xoutput91 _623_/Y VGND VGND VPWR VPWR S[3] sky130_fd_sc_hd__buf_6
Xoutput80 _497_/Y VGND VGND VPWR VPWR S[22] sky130_fd_sc_hd__buf_6
XFILLER_11_28 VGND VGND VPWR VPWR sky130_fd_sc_hd__fill_2
XFILLER_31_183 VGND VGND VPWR VPWR sky130_fd_sc_hd__decap_3
XFILLER_31_172 VGND VGND VPWR VPWR sky130_fd_sc_hd__decap_3
XFILLER_14_106 VGND VGND VPWR VPWR sky130_fd_sc_hd__decap_3
XFILLER_14_139 VGND VGND VPWR VPWR sky130_fd_sc_hd__fill_1
XFILLER_22_161 VGND VGND VPWR VPWR sky130_fd_sc_hd__decap_3
X_506_ _506_/A _506_/B _506_/C VGND VGND VPWR VPWR _507_/B sky130_fd_sc_hd__and3_2
XFILLER_26_91 VGND VGND VPWR VPWR sky130_fd_sc_hd__decap_3
X_437_ _437_/A _437_/B VGND VGND VPWR VPWR _437_/Y sky130_fd_sc_hd__nor2_2
X_368_ _361_/X _364_/Y _376_/B VGND VGND VPWR VPWR _625_/A sky130_fd_sc_hd__o21a_2
XFILLER_9_154 VGND VGND VPWR VPWR sky130_fd_sc_hd__decap_3
XFILLER_9_110 VGND VGND VPWR VPWR sky130_fd_sc_hd__fill_2
XFILLER_28_209 VGND VGND VPWR VPWR sky130_fd_sc_hd__fill_2
XFILLER_0_9 VGND VGND VPWR VPWR sky130_fd_sc_hd__decap_3
Xfanout111 input65/X VGND VGND VPWR VPWR _473_/A sky130_fd_sc_hd__dlygate4sd1_1
XPHY_EDGE_ROW_29_Right_29 VGND VGND VPWR VPWR sky130_fd_sc_hd__decap_3
XFILLER_10_131 VGND VGND VPWR VPWR sky130_fd_sc_hd__decap_3
XFILLER_10_153 VGND VGND VPWR VPWR sky130_fd_sc_hd__decap_3
XFILLER_10_175 VGND VGND VPWR VPWR sky130_fd_sc_hd__decap_3
XFILLER_8_29 VGND VGND VPWR VPWR sky130_fd_sc_hd__decap_3
XFILLER_6_135 VGND VGND VPWR VPWR sky130_fd_sc_hd__decap_3
XFILLER_12_82 VGND VGND VPWR VPWR sky130_fd_sc_hd__fill_2
XFILLER_33_15 VGND VGND VPWR VPWR sky130_fd_sc_hd__decap_3
XFILLER_31_6 VGND VGND VPWR VPWR sky130_fd_sc_hd__decap_3
X_685_ _683_/Y _678_/Y _692_/A VGND VGND VPWR VPWR _685_/Y sky130_fd_sc_hd__o21ai_4
XTAP_TAPCELL_ROW_5_95 VGND VPWR sky130_fd_sc_hd__tapvpwrvgnd_1
XFILLER_30_38 VGND VGND VPWR VPWR sky130_fd_sc_hd__decap_3
XFILLER_30_49 VGND VGND VPWR VPWR sky130_fd_sc_hd__decap_3
X_470_ _452_/Y _466_/X _425_/B _465_/Y VGND VGND VPWR VPWR _507_/A sky130_fd_sc_hd__o22ai_4
XFILLER_4_200 VGND VGND VPWR VPWR sky130_fd_sc_hd__decap_3
XFILLER_20_93 VGND VGND VPWR VPWR sky130_fd_sc_hd__decap_3
X_599_ _605_/A _605_/D VGND VGND VPWR VPWR _611_/A sky130_fd_sc_hd__nand2_2
X_668_ _669_/A _669_/B VGND VGND VPWR VPWR _668_/X sky130_fd_sc_hd__and2_4
XFILLER_26_115 VGND VGND VPWR VPWR sky130_fd_sc_hd__decap_3
Xrebuffer157 _499_/X VGND VGND VPWR VPWR _514_/A1 sky130_fd_sc_hd__buf_4
Xrebuffer135 _575_/A1 VGND VGND VPWR VPWR _529_/A1 sky130_fd_sc_hd__buf_2
Xrebuffer124 _418_/A VGND VGND VPWR VPWR _622_/A sky130_fd_sc_hd__buf_2
X_522_ _523_/A _523_/B VGND VGND VPWR VPWR _522_/X sky130_fd_sc_hd__and2_2
X_453_ _450_/A _450_/B _452_/A VGND VGND VPWR VPWR _456_/C sky130_fd_sc_hd__o21bai_2
XFILLER_17_137 VGND VGND VPWR VPWR sky130_fd_sc_hd__decap_3
XFILLER_17_104 VGND VGND VPWR VPWR sky130_fd_sc_hd__decap_3
XFILLER_15_82 VGND VGND VPWR VPWR sky130_fd_sc_hd__decap_3
X_384_ _384_/A _384_/B VGND VGND VPWR VPWR _384_/Y sky130_fd_sc_hd__nor2_2
Xoutput70 _644_/Y VGND VGND VPWR VPWR S[13] sky130_fd_sc_hd__dlymetal6s4s_1
XTAP_TAPCELL_ROW_2_85 VGND VPWR sky130_fd_sc_hd__tapvpwrvgnd_1
XFILLER_31_70 VGND VGND VPWR VPWR sky130_fd_sc_hd__decap_3
Xoutput92 _625_/Y VGND VGND VPWR VPWR S[4] sky130_fd_sc_hd__clkbuf_2
Xoutput81 _513_/Y VGND VGND VPWR VPWR S[23] sky130_fd_sc_hd__buf_4
XFILLER_16_192 VGND VGND VPWR VPWR sky130_fd_sc_hd__decap_3
XFILLER_31_140 VGND VGND VPWR VPWR sky130_fd_sc_hd__decap_3
XFILLER_23_129 VGND VGND VPWR VPWR sky130_fd_sc_hd__decap_3
XFILLER_31_195 VGND VGND VPWR VPWR sky130_fd_sc_hd__decap_3
XFILLER_14_118 VGND VGND VPWR VPWR sky130_fd_sc_hd__decap_3
XTAP_TAPCELL_ROW_32_190 VGND VPWR sky130_fd_sc_hd__tapvpwrvgnd_1
XFILLER_22_173 VGND VGND VPWR VPWR sky130_fd_sc_hd__decap_3
XFILLER_13_151 VGND VGND VPWR VPWR sky130_fd_sc_hd__decap_3
X_505_ _505_/A1 _502_/Y _505_/B1 VGND VGND VPWR VPWR _505_/Y sky130_fd_sc_hd__o21ai_2
X_436_ _473_/A _436_/B VGND VGND VPWR VPWR _438_/B sky130_fd_sc_hd__nand2_2
XFILLER_26_81 VGND VGND VPWR VPWR sky130_fd_sc_hd__decap_3
X_367_ _364_/B1 _367_/B _367_/C VGND VGND VPWR VPWR _376_/B sky130_fd_sc_hd__nand3b_2
XFILLER_9_166 VGND VGND VPWR VPWR sky130_fd_sc_hd__fill_2
XTAP_TAPCELL_ROW_21_149 VGND VPWR sky130_fd_sc_hd__tapvpwrvgnd_1
Xfanout101 fanout105/X VGND VGND VPWR VPWR _388_/A sky130_fd_sc_hd__buf_6
Xfanout112 fanout121/X VGND VGND VPWR VPWR _652_/A sky130_fd_sc_hd__buf_6
XFILLER_12_61 VGND VGND VPWR VPWR sky130_fd_sc_hd__decap_3
XFILLER_12_94 VGND VGND VPWR VPWR sky130_fd_sc_hd__decap_3
XFILLER_33_202 VGND VGND VPWR VPWR sky130_fd_sc_hd__decap_3
X_419_ _399_/X _401_/Y _418_/Y _417_/Y VGND VGND VPWR VPWR _420_/A sky130_fd_sc_hd__o22ai_4
XFILLER_17_39 VGND VGND VPWR VPWR sky130_fd_sc_hd__fill_2
XFILLER_23_93 VGND VGND VPWR VPWR sky130_fd_sc_hd__fill_2
XFILLER_23_71 VGND VGND VPWR VPWR sky130_fd_sc_hd__fill_1
XFILLER_23_60 VGND VGND VPWR VPWR sky130_fd_sc_hd__decap_3
XFILLER_2_194 VGND VGND VPWR VPWR sky130_fd_sc_hd__fill_2
XFILLER_0_42 VGND VGND VPWR VPWR sky130_fd_sc_hd__fill_1
XFILLER_9_95 VGND VGND VPWR VPWR sky130_fd_sc_hd__decap_3
XFILLER_28_27 VGND VGND VPWR VPWR sky130_fd_sc_hd__fill_1
X_684_ _679_/Y _682_/X _692_/A VGND VGND VPWR VPWR _684_/Y sky130_fd_sc_hd__a21boi_2
XFILLER_18_71 VGND VGND VPWR VPWR sky130_fd_sc_hd__decap_3
XFILLER_34_81 VGND VGND VPWR VPWR sky130_fd_sc_hd__decap_3
XFILLER_29_157 VGND VGND VPWR VPWR sky130_fd_sc_hd__decap_3
XFILLER_29_113 VGND VGND VPWR VPWR sky130_fd_sc_hd__fill_1
XFILLER_29_70 VGND VGND VPWR VPWR sky130_fd_sc_hd__fill_1
X_598_ _577_/B _577_/A _605_/D VGND VGND VPWR VPWR _598_/Y sky130_fd_sc_hd__a21boi_2
X_667_ _669_/A _669_/B VGND VGND VPWR VPWR _667_/Y sky130_fd_sc_hd__nor2_2
XFILLER_26_127 VGND VGND VPWR VPWR sky130_fd_sc_hd__decap_3
XFILLER_19_190 VGND VGND VPWR VPWR sky130_fd_sc_hd__decap_3
Xrebuffer158 _493_/Y VGND VGND VPWR VPWR _506_/C sky130_fd_sc_hd__buf_2
Xrebuffer147 _507_/A VGND VGND VPWR VPWR _487_/A1_N sky130_fd_sc_hd__buf_2
Xrebuffer136 _575_/A1 VGND VGND VPWR VPWR _559_/A2 sky130_fd_sc_hd__buf_2
Xrebuffer125 _517_/Y VGND VGND VPWR VPWR _576_/A2 sky130_fd_sc_hd__buf_2
X_521_ _523_/A _523_/B VGND VGND VPWR VPWR _521_/Y sky130_fd_sc_hd__nor2_2
X_452_ _452_/A _452_/B VGND VGND VPWR VPWR _452_/Y sky130_fd_sc_hd__nor2_2
X_383_ _383_/A _383_/B VGND VGND VPWR VPWR _384_/B sky130_fd_sc_hd__nand2_4
XFILLER_25_193 VGND VGND VPWR VPWR sky130_fd_sc_hd__fill_2
XFILLER_17_149 VGND VGND VPWR VPWR sky130_fd_sc_hd__decap_3
XFILLER_17_116 VGND VGND VPWR VPWR sky130_fd_sc_hd__decap_3
Xoutput93 _627_/Y VGND VGND VPWR VPWR S[5] sky130_fd_sc_hd__buf_2
Xoutput82 _531_/X VGND VGND VPWR VPWR S[24] sky130_fd_sc_hd__buf_6
Xoutput71 _647_/X VGND VGND VPWR VPWR S[14] sky130_fd_sc_hd__clkbuf_4
X_719_ _717_/A _717_/B _718_/Y VGND VGND VPWR VPWR _719_/Y sky130_fd_sc_hd__a21oi_2
XFILLER_16_171 VGND VGND VPWR VPWR sky130_fd_sc_hd__decap_3
XFILLER_23_108 VGND VGND VPWR VPWR sky130_fd_sc_hd__decap_3
XFILLER_22_152 VGND VGND VPWR VPWR sky130_fd_sc_hd__decap_3
XFILLER_22_141 VGND VGND VPWR VPWR sky130_fd_sc_hd__fill_2
X_504_ _505_/A1 _502_/Y _505_/B1 VGND VGND VPWR VPWR _504_/X sky130_fd_sc_hd__o21a_2
X_435_ _473_/A _436_/B VGND VGND VPWR VPWR _437_/B sky130_fd_sc_hd__and2_4
X_366_ _364_/B1 _367_/B _367_/C VGND VGND VPWR VPWR _366_/X sky130_fd_sc_hd__and3b_2
XFILLER_9_101 VGND VGND VPWR VPWR sky130_fd_sc_hd__decap_3
XFILLER_26_60 VGND VGND VPWR VPWR sky130_fd_sc_hd__decap_3
XFILLER_9_145 VGND VGND VPWR VPWR sky130_fd_sc_hd__decap_3
XFILLER_3_86 VGND VGND VPWR VPWR sky130_fd_sc_hd__fill_2
XFILLER_3_64 VGND VGND VPWR VPWR sky130_fd_sc_hd__fill_2
XFILLER_3_42 VGND VGND VPWR VPWR sky130_fd_sc_hd__decap_3
XFILLER_22_29 VGND VGND VPWR VPWR sky130_fd_sc_hd__fill_1
XFILLER_10_100 VGND VGND VPWR VPWR sky130_fd_sc_hd__fill_2
XTAP_TAPCELL_ROW_12_117 VGND VPWR sky130_fd_sc_hd__tapvpwrvgnd_1
XFILLER_10_122 VGND VGND VPWR VPWR sky130_fd_sc_hd__decap_3
XFILLER_10_144 VGND VGND VPWR VPWR sky130_fd_sc_hd__decap_3
XFILLER_10_166 VGND VGND VPWR VPWR sky130_fd_sc_hd__decap_3
XFILLER_12_73 VGND VGND VPWR VPWR sky130_fd_sc_hd__decap_3
X_418_ _418_/A _418_/B VGND VGND VPWR VPWR _418_/Y sky130_fd_sc_hd__nand2_2
X_349_ _728_/A _728_/B _730_/Y VGND VGND VPWR VPWR _406_/D sky130_fd_sc_hd__a21o_2
XFILLER_2_173 VGND VGND VPWR VPWR sky130_fd_sc_hd__decap_3
XFILLER_0_32 VGND VGND VPWR VPWR sky130_fd_sc_hd__fill_1
XFILLER_21_206 VGND VGND VPWR VPWR sky130_fd_sc_hd__decap_3
XFILLER_9_85 VGND VGND VPWR VPWR sky130_fd_sc_hd__decap_3
XFILLER_9_63 VGND VGND VPWR VPWR sky130_fd_sc_hd__decap_3
XFILLER_9_52 VGND VGND VPWR VPWR sky130_fd_sc_hd__decap_3
XFILLER_28_39 VGND VGND VPWR VPWR sky130_fd_sc_hd__decap_3
XPHY_EDGE_ROW_8_Left_44 VGND VGND VPWR VPWR sky130_fd_sc_hd__decap_3
X_683_ input6/X _665_/Y _692_/B VGND VGND VPWR VPWR _683_/Y sky130_fd_sc_hd__o21ai_2
XFILLER_18_94 VGND VGND VPWR VPWR sky130_fd_sc_hd__decap_3
XFILLER_18_83 VGND VGND VPWR VPWR sky130_fd_sc_hd__fill_1
Xload_slew113 _652_/A VGND VGND VPWR VPWR _726_/B sky130_fd_sc_hd__buf_6
Xload_slew102 _388_/A VGND VGND VPWR VPWR _351_/B sky130_fd_sc_hd__buf_8
XFILLER_29_136 VGND VGND VPWR VPWR sky130_fd_sc_hd__decap_3
XFILLER_29_169 VGND VGND VPWR VPWR sky130_fd_sc_hd__decap_3
XFILLER_29_60 VGND VGND VPWR VPWR sky130_fd_sc_hd__fill_1
X_597_ _597_/A _597_/B _597_/C _597_/D VGND VGND VPWR VPWR _605_/D sky130_fd_sc_hd__and4_2
X_666_ _664_/A _664_/B input6/X VGND VGND VPWR VPWR _666_/Y sky130_fd_sc_hd__o21ai_2
XFILLER_28_191 VGND VGND VPWR VPWR sky130_fd_sc_hd__decap_3
XFILLER_26_139 VGND VGND VPWR VPWR sky130_fd_sc_hd__fill_1
XFILLER_26_106 VGND VGND VPWR VPWR sky130_fd_sc_hd__decap_3
XFILLER_25_18 VGND VGND VPWR VPWR sky130_fd_sc_hd__fill_2
Xrebuffer137 rebuffer156/X VGND VGND VPWR VPWR _505_/A1 sky130_fd_sc_hd__buf_2
Xrebuffer126 _491_/Y VGND VGND VPWR VPWR _506_/B sky130_fd_sc_hd__buf_2
XFILLER_1_205 VGND VGND VPWR VPWR sky130_fd_sc_hd__decap_3
X_520_ _520_/A1 _685_/Y _422_/Y _520_/B2 _518_/X VGND VGND VPWR VPWR _520_/Y sky130_fd_sc_hd__o221ai_4
X_451_ _452_/B _452_/A VGND VGND VPWR VPWR _466_/B sky130_fd_sc_hd__nand2_2
X_382_ _428_/A _382_/B VGND VGND VPWR VPWR _384_/A sky130_fd_sc_hd__nor2_4
XFILLER_25_172 VGND VGND VPWR VPWR sky130_fd_sc_hd__decap_3
XFILLER_25_150 VGND VGND VPWR VPWR sky130_fd_sc_hd__decap_3
Xoutput94 _629_/Y VGND VGND VPWR VPWR S[6] sky130_fd_sc_hd__buf_6
Xoutput83 _540_/Y VGND VGND VPWR VPWR S[25] sky130_fd_sc_hd__buf_6
Xoutput72 _650_/Y VGND VGND VPWR VPWR S[15] sky130_fd_sc_hd__clkbuf_2
XFILLER_16_150 VGND VGND VPWR VPWR sky130_fd_sc_hd__decap_3
X_649_ _692_/A _692_/B _648_/D _680_/Y VGND VGND VPWR VPWR _650_/B sky130_fd_sc_hd__a22oi_2
X_718_ _718_/A1 _717_/B input3/X VGND VGND VPWR VPWR _718_/Y sky130_fd_sc_hd__o21ai_2
XFILLER_31_186 VGND VGND VPWR VPWR sky130_fd_sc_hd__decap_3
XFILLER_31_175 VGND VGND VPWR VPWR sky130_fd_sc_hd__fill_1
XFILLER_31_120 VGND VGND VPWR VPWR sky130_fd_sc_hd__decap_3
XFILLER_14_109 VGND VGND VPWR VPWR sky130_fd_sc_hd__decap_3
XTAP_TAPCELL_ROW_24_159 VGND VPWR sky130_fd_sc_hd__tapvpwrvgnd_1
XFILLER_22_164 VGND VGND VPWR VPWR sky130_fd_sc_hd__decap_3
X_503_ _499_/A _499_/B _502_/Y VGND VGND VPWR VPWR _503_/X sky130_fd_sc_hd__a21o_2
XFILLER_13_142 VGND VGND VPWR VPWR sky130_fd_sc_hd__decap_3
X_434_ _592_/A _436_/B VGND VGND VPWR VPWR _437_/A sky130_fd_sc_hd__nor2_4
X_365_ _363_/B _362_/B _364_/Y VGND VGND VPWR VPWR _406_/B sky130_fd_sc_hd__a21oi_2
XPHY_EDGE_ROW_21_Left_57 VGND VGND VPWR VPWR sky130_fd_sc_hd__decap_3
XFILLER_9_157 VGND VGND VPWR VPWR sky130_fd_sc_hd__decap_3
XFILLER_26_94 VGND VGND VPWR VPWR sky130_fd_sc_hd__decap_3
XFILLER_26_72 VGND VGND VPWR VPWR sky130_fd_sc_hd__decap_3
XFILLER_9_179 VGND VGND VPWR VPWR sky130_fd_sc_hd__decap_3
XFILLER_3_54 VGND VGND VPWR VPWR sky130_fd_sc_hd__fill_2
XFILLER_22_19 VGND VGND VPWR VPWR sky130_fd_sc_hd__fill_1
Xfanout103 fanout105/X VGND VGND VPWR VPWR _566_/A sky130_fd_sc_hd__buf_6
Xfanout114 fanout121/X VGND VGND VPWR VPWR _669_/A sky130_fd_sc_hd__buf_4
XFILLER_10_134 VGND VGND VPWR VPWR sky130_fd_sc_hd__decap_3
XTAP_TAPCELL_ROW_12_118 VGND VPWR sky130_fd_sc_hd__tapvpwrvgnd_1
XFILLER_10_156 VGND VGND VPWR VPWR sky130_fd_sc_hd__decap_3
XFILLER_10_178 VGND VGND VPWR VPWR sky130_fd_sc_hd__decap_3
XFILLER_12_52 VGND VGND VPWR VPWR sky130_fd_sc_hd__decap_3
XFILLER_12_85 VGND VGND VPWR VPWR sky130_fd_sc_hd__decap_3
XFILLER_6_138 VGND VGND VPWR VPWR sky130_fd_sc_hd__fill_2
XPHY_EDGE_ROW_16_Right_16 VGND VGND VPWR VPWR sky130_fd_sc_hd__decap_3
X_417_ _385_/Y _390_/Y _416_/Y VGND VGND VPWR VPWR _417_/Y sky130_fd_sc_hd__a21oi_2
XPHY_EDGE_ROW_25_Right_25 VGND VGND VPWR VPWR sky130_fd_sc_hd__decap_3
XFILLER_5_182 VGND VGND VPWR VPWR sky130_fd_sc_hd__decap_3
XFILLER_5_160 VGND VGND VPWR VPWR sky130_fd_sc_hd__decap_3
XPHY_EDGE_ROW_34_Right_34 VGND VGND VPWR VPWR sky130_fd_sc_hd__decap_3
XFILLER_33_18 VGND VGND VPWR VPWR sky130_fd_sc_hd__decap_3
XFILLER_23_84 VGND VGND VPWR VPWR sky130_fd_sc_hd__decap_3
XFILLER_23_51 VGND VGND VPWR VPWR sky130_fd_sc_hd__decap_3
XFILLER_31_9 VGND VGND VPWR VPWR sky130_fd_sc_hd__fill_1
XFILLER_2_152 VGND VGND VPWR VPWR sky130_fd_sc_hd__decap_3
XFILLER_2_141 VGND VGND VPWR VPWR sky130_fd_sc_hd__fill_2
XFILLER_9_20 VGND VGND VPWR VPWR sky130_fd_sc_hd__fill_1
XPHY_EDGE_ROW_24_Left_60 VGND VGND VPWR VPWR sky130_fd_sc_hd__decap_3
X_682_ input6/X _665_/Y _692_/B VGND VGND VPWR VPWR _682_/X sky130_fd_sc_hd__o21a_2
XFILLER_18_62 VGND VGND VPWR VPWR sky130_fd_sc_hd__decap_3
XFILLER_18_40 VGND VGND VPWR VPWR sky130_fd_sc_hd__decap_3
XFILLER_34_94 VGND VGND VPWR VPWR sky130_fd_sc_hd__decap_3
XPHY_EDGE_ROW_2_Right_2 VGND VGND VPWR VPWR sky130_fd_sc_hd__decap_3
XFILLER_29_148 VGND VGND VPWR VPWR sky130_fd_sc_hd__decap_3
XFILLER_4_203 VGND VGND VPWR VPWR sky130_fd_sc_hd__decap_3
XFILLER_20_96 VGND VGND VPWR VPWR sky130_fd_sc_hd__decap_3
XFILLER_20_85 VGND VGND VPWR VPWR sky130_fd_sc_hd__decap_3
XFILLER_20_52 VGND VGND VPWR VPWR sky130_fd_sc_hd__decap_3
X_665_ _665_/A _665_/B VGND VGND VPWR VPWR _665_/Y sky130_fd_sc_hd__nor2_2
XFILLER_28_170 VGND VGND VPWR VPWR sky130_fd_sc_hd__decap_3
X_596_ _605_/B _605_/C VGND VGND VPWR VPWR _596_/Y sky130_fd_sc_hd__nand2_2
XFILLER_6_98 VGND VGND VPWR VPWR sky130_fd_sc_hd__fill_2
XFILLER_6_32 VGND VGND VPWR VPWR sky130_fd_sc_hd__decap_3
XFILLER_26_118 VGND VGND VPWR VPWR sky130_fd_sc_hd__decap_3
XFILLER_19_181 VGND VGND VPWR VPWR sky130_fd_sc_hd__fill_2
Xrebuffer138 fanout121/X VGND VGND VPWR VPWR _718_/A1 sky130_fd_sc_hd__buf_2
Xrebuffer127 fanout108/X VGND VGND VPWR VPWR _656_/B sky130_fd_sc_hd__buf_2
XFILLER_17_107 VGND VGND VPWR VPWR sky130_fd_sc_hd__decap_3
XFILLER_15_85 VGND VGND VPWR VPWR sky130_fd_sc_hd__decap_3
X_450_ _450_/A _450_/B VGND VGND VPWR VPWR _452_/B sky130_fd_sc_hd__nor2_2
X_381_ _428_/A _382_/B VGND VGND VPWR VPWR _383_/A sky130_fd_sc_hd__nand2_2
XFILLER_31_84 VGND VGND VPWR VPWR sky130_fd_sc_hd__fill_1
XFILLER_31_73 VGND VGND VPWR VPWR sky130_fd_sc_hd__decap_3
Xoutput95 _631_/X VGND VGND VPWR VPWR S[7] sky130_fd_sc_hd__buf_2
Xoutput84 _552_/Y VGND VGND VPWR VPWR S[26] sky130_fd_sc_hd__buf_6
Xoutput73 _425_/X VGND VGND VPWR VPWR S[16] sky130_fd_sc_hd__buf_6
XFILLER_16_162 VGND VGND VPWR VPWR sky130_fd_sc_hd__decap_3
X_648_ _692_/A _680_/Y _692_/B _648_/D VGND VGND VPWR VPWR _650_/A sky130_fd_sc_hd__and4_2
X_717_ _717_/A _717_/B VGND VGND VPWR VPWR _717_/X sky130_fd_sc_hd__and2_4
XFILLER_16_195 VGND VGND VPWR VPWR sky130_fd_sc_hd__fill_1
X_579_ _577_/B _577_/A _570_/Y VGND VGND VPWR VPWR _579_/Y sky130_fd_sc_hd__a21oi_4
XFILLER_31_198 VGND VGND VPWR VPWR sky130_fd_sc_hd__decap_3
XFILLER_31_165 VGND VGND VPWR VPWR sky130_fd_sc_hd__decap_3
XFILLER_31_143 VGND VGND VPWR VPWR sky130_fd_sc_hd__decap_3
XFILLER_22_176 VGND VGND VPWR VPWR sky130_fd_sc_hd__decap_3
XFILLER_22_132 VGND VGND VPWR VPWR sky130_fd_sc_hd__fill_2
XFILLER_22_121 VGND VGND VPWR VPWR sky130_fd_sc_hd__decap_3
X_502_ _499_/A _499_/B _502_/B1 VGND VGND VPWR VPWR _502_/Y sky130_fd_sc_hd__o21ai_2
X_433_ _464_/B _433_/B VGND VGND VPWR VPWR _433_/X sky130_fd_sc_hd__xor2_2
XFILLER_26_51 VGND VGND VPWR VPWR sky130_fd_sc_hd__decap_3
XFILLER_26_40 VGND VGND VPWR VPWR sky130_fd_sc_hd__decap_3
XFILLER_13_154 VGND VGND VPWR VPWR sky130_fd_sc_hd__decap_3
XFILLER_13_165 VGND VGND VPWR VPWR sky130_fd_sc_hd__decap_3
X_364_ _363_/B _362_/B _364_/B1 VGND VGND VPWR VPWR _364_/Y sky130_fd_sc_hd__o21ai_2
XFILLER_9_169 VGND VGND VPWR VPWR sky130_fd_sc_hd__decap_3
XFILLER_9_136 VGND VGND VPWR VPWR sky130_fd_sc_hd__decap_3
XTAP_TAPCELL_ROW_12_119 VGND VPWR sky130_fd_sc_hd__tapvpwrvgnd_1
XFILLER_12_64 VGND VGND VPWR VPWR sky130_fd_sc_hd__decap_3
XFILLER_12_97 VGND VGND VPWR VPWR sky130_fd_sc_hd__decap_3
XFILLER_5_3 VGND VGND VPWR VPWR sky130_fd_sc_hd__decap_3
XFILLER_18_202 VGND VGND VPWR VPWR sky130_fd_sc_hd__fill_1
X_416_ _384_/A _384_/B _395_/X _397_/Y VGND VGND VPWR VPWR _416_/Y sky130_fd_sc_hd__o22ai_2
XFILLER_33_205 VGND VGND VPWR VPWR sky130_fd_sc_hd__decap_3
XFILLER_23_30 VGND VGND VPWR VPWR sky130_fd_sc_hd__decap_3
XFILLER_2_120 VGND VGND VPWR VPWR sky130_fd_sc_hd__decap_3
XFILLER_0_12 VGND VGND VPWR VPWR sky130_fd_sc_hd__decap_3
XFILLER_9_76 VGND VGND VPWR VPWR sky130_fd_sc_hd__decap_3
XFILLER_9_98 VGND VGND VPWR VPWR sky130_fd_sc_hd__decap_3
X_681_ _662_/B _662_/A input7/X VGND VGND VPWR VPWR _692_/B sky130_fd_sc_hd__o21bai_2
XFILLER_18_85 VGND VGND VPWR VPWR sky130_fd_sc_hd__decap_3
XFILLER_18_74 VGND VGND VPWR VPWR sky130_fd_sc_hd__decap_3
Xload_slew115 _669_/A VGND VGND VPWR VPWR _717_/A sky130_fd_sc_hd__buf_6
Xload_slew104 _566_/A VGND VGND VPWR VPWR _426_/A sky130_fd_sc_hd__buf_8
X_595_ _593_/A _593_/B input24/X VGND VGND VPWR VPWR _605_/C sky130_fd_sc_hd__o21bai_2
X_664_ _664_/A _664_/B VGND VGND VPWR VPWR _665_/B sky130_fd_sc_hd__nor2_2
XFILLER_6_44 VGND VGND VPWR VPWR sky130_fd_sc_hd__decap_3
XFILLER_20_3 VGND VGND VPWR VPWR sky130_fd_sc_hd__decap_3
XFILLER_34_141 VGND VGND VPWR VPWR sky130_fd_sc_hd__fill_1
XFILLER_19_193 VGND VGND VPWR VPWR sky130_fd_sc_hd__decap_3
Xrebuffer139 fanout121/X VGND VGND VPWR VPWR _546_/A sky130_fd_sc_hd__buf_2
Xrebuffer128 _507_/A VGND VGND VPWR VPWR _511_/A1 sky130_fd_sc_hd__buf_2
XFILLER_17_119 VGND VGND VPWR VPWR sky130_fd_sc_hd__fill_2
XFILLER_15_42 VGND VGND VPWR VPWR sky130_fd_sc_hd__decap_3
XFILLER_15_53 VGND VGND VPWR VPWR sky130_fd_sc_hd__decap_3
X_380_ _727_/A _382_/B VGND VGND VPWR VPWR _385_/C sky130_fd_sc_hd__nand2_2
XFILLER_31_30 VGND VGND VPWR VPWR sky130_fd_sc_hd__decap_3
X_716_ _716_/A _716_/B VGND VGND VPWR VPWR _716_/Y sky130_fd_sc_hd__nand2_2
Xoutput96 _633_/Y VGND VGND VPWR VPWR S[8] sky130_fd_sc_hd__clkbuf_2
Xoutput85 _564_/Y VGND VGND VPWR VPWR S[27] sky130_fd_sc_hd__buf_6
Xoutput74 _433_/X VGND VGND VPWR VPWR S[17] sky130_fd_sc_hd__buf_6
XFILLER_16_130 VGND VGND VPWR VPWR sky130_fd_sc_hd__decap_3
XFILLER_16_141 VGND VGND VPWR VPWR sky130_fd_sc_hd__decap_3
XFILLER_16_174 VGND VGND VPWR VPWR sky130_fd_sc_hd__decap_3
X_578_ _693_/X _447_/D _578_/A3 _576_/Y VGND VGND VPWR VPWR _578_/Y sky130_fd_sc_hd__a31oi_2
X_647_ _688_/X _647_/B VGND VGND VPWR VPWR _647_/X sky130_fd_sc_hd__xor2_2
XFILLER_31_111 VGND VGND VPWR VPWR sky130_fd_sc_hd__fill_1
.ends
